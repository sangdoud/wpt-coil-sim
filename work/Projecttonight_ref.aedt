# Ansys Electronics Desktop project, version 2024.1
materials:
  vacuum: permittivity=1
  copper: permeability=0.999991 conductivity=58000000
  ferrite: permittivity=12 permeability=1000
  air: permittivity=1.0006 permeability=1.0000004
surface materials:
  Steel-oxidised-surface

design WPT_G (Maxwell 3D, Magnetostatic, model units mm)
geometry:
  Tx1 [copper] = polyline(z=0.325mm, xy in mm: (30.417297, -15.208649) (30.488579, -11.459951) (30.559862, -7.6756103) (30.631145, -3.8556266) (30.702427, 0) (30.773709, 3.8912706) (30.844992, 7.8181841) (30.916275, 11.780741) (30.987557, 15.77894) (30.766643, 18.817299) (29.972564, 21.741688) (28.638577, 24.44249) (26.818684, 26.818684) (24.585058, 28.781142) (22.026827, 30.257694) (19.245012, 31.194337) (16.34923, 31.557816) (12.315387, 31.629098) (8.2459006, 31.700381) (4.1407717, 31.771664) (0, 31.842946) (-4.1764155, 31.914227) (-8.3884739, 31.98551) (-12.636175, 32.056793) (-16.919519, 32.128075) (-19.957866, 31.907161) (-22.882242, 31.113083) (-25.583028, 29.779096) (-27.959203, 27.959203) (-29.92166, 25.725595) (-31.398212, 23.16738) (-32.334856, 20.385577) (-32.698334, 17.489807) (-32.769616, 13.170819) (-32.840899, 8.8161888) (-32.912182, 4.4259157) (-32.983464, 0) (-33.054746, -4.4615594) (-33.126029, -8.9587616) (-33.197312, -13.491606) (-33.268594, -18.060094) (-33.04768, -21.098429) (-32.253601, -24.022793) (-30.919614, -26.723565) (-29.099722, -29.099722) (-26.866132, -31.062179) (-24.30793, -32.538731) (-21.52614, -33.475374) (-18.63038, -33.838853) (-14.026249, -33.910135) (-9.386475, -33.981418) (-4.7110588, -34.052701) (0, -34.123983) (4.7467024, -34.195265) (9.5290473, -34.266547) (14.347035, -34.33783) (19.200665, -34.409112) (22.23899, -34.188198) (25.163342, -33.39412) (27.8641, -32.060133) (30.24024, -30.24024) (32.202698, -28.006667) (33.679249, -25.448478) (34.615893, -22.666699) (34.979372, -19.770949) (35.050653, -14.881676) (35.121936, -9.9567595) (35.193219, -4.996201) (35.264501, 0) (35.335783, 5.0318445) (35.407066, 10.099331) (35.478349, 15.202461) (35.549631, 20.341233) (35.328717, 23.379547) (34.534638, 26.303888) (33.200651, 29.004634) (31.380759, 31.380759) (29.147201, 33.343216) (26.589025, 34.819768) (23.807256, 35.756411) (20.911515, 36.11989) (15.7371, 36.191172) (10.527042, 36.262455) (5.2813424, 36.333738) (0, 36.40502) (-5.3169858, 36.476302) (-10.669614, 36.547585) (-16.057884, 36.618868) (-21.481797, 36.690149) (-24.520103, 36.469236) (-27.444433, 35.675157) (-30.145167, 34.34117) (-32.521277, 32.521277) (-34.483735, 30.287734) (-35.960286, 27.729569) (-36.89693, 24.94781) (-37.260409, 22.052079) (-37.331691, 16.592522) (-37.402974, 11.097324) (-37.474256, 5.5664831) (-37.545538, 0) (-37.61682, -5.6021264) (-37.688103, -11.239895) (-37.759386, -16.913306) (-37.830668, -22.622359) (-37.609754, -25.660656) (-36.815675, -28.584977) (-35.481688, -31.2857) (-33.661796, -33.661796) (-31.428266, -35.624253) (-28.870112, -37.100805) (-26.088362, -38.037449) (-23.192639, -38.400927) (-17.447943, -38.472209) (-11.667604, -38.543492) (-5.8516231, -38.614775) (0, -38.686057) (5.8872664, -38.757339) (11.810175, -38.828622) (17.768726, -38.899905) (23.762919, -38.971187) (26.801207, -38.750273) (29.725519, -37.956194) (32.426231, -36.622207) (34.802314, -34.802314) (36.764772, -32.568797) (38.241324, -30.010654) (39.177967, -27.228913) (39.541446, -24.333197) (39.612728, -18.303361) (39.684011, -12.237883) (39.755294, -6.1367626) (39.826576, 0) (39.897857, 6.1724057) (39.96914, 12.380454) (40.040423, 18.624144) (40.111705, 24.903476) (39.890791, 27.941756) (39.096713, 30.866059) (37.762726, 33.566762) (35.942833, 35.942833) (33.709328, 37.90529) (31.151194, 39.381842) (28.369461, 40.318486) (25.473753, 40.681964) (19.158778, 40.753246) (12.808161, 40.824529) (6.4219015, 40.895812) (0, 40.967094) (-6.4575446, 41.038376) (-12.950731, 41.109659) (-19.47956, 41.180942) (-26.044031, 41.252224) (-29.082303, 41.03131) (-32.006598, 40.237231) (-34.707291, 38.903244) (-37.083352, 37.083352) (-39.045809, 34.849858) (-40.522361, 32.291733) (-41.459004, 29.510008) (-41.822483, 26.614307) (-41.893765, 20.014194) (-41.965048, 13.378438) (-42.036331, 6.7070399) (-42.107613, 0) (-42.178895, -6.7426829) (-42.250177, -13.521008) (-42.32146, -20.334975) (-42.392742, -27.184584) (-42.171828, -30.222849) (-41.37775, -33.147137) (-40.043763, -35.847821) (-38.22387, -38.22387) (-35.990387, -40.186328) (-33.432271, -41.662879) (-30.650553, -42.599523) (-27.754859, -42.963002) (-20.869608, -43.034283) (-13.948714, -43.105566) (-6.9921778, -43.176849) (0, -43.248131) (7.0278208, -43.319413) (14.091284, -43.390696) (21.190388, -43.461979) (28.325135, -43.533261) (31.363394, -43.312347) (34.287674, -42.518268) (36.988349, -41.184281) (39.364389, -39.364389) (41.326846, -37.130915) (42.803398, -34.572808) (43.740041, -31.791097) (44.10352, -28.89541) (44.174802, -21.72502) (44.246085, -14.518989) (44.317368, -7.2773153) (44.38865, 0) (44.459932, 7.3129582) (44.531215, 14.661558) (44.602498, 22.0458) (44.673779, 29.465684) (44.452866, 32.503937) (43.658787, 35.42821) (42.3248, 38.128877) (40.504907, 40.504907) (38.271443, 42.467365) (35.713344, 43.943917) (32.93164, 44.88056) (30.035958, 45.244039) (22.580432, 45.315321) (15.089263, 45.386604) (7.5624524, 45.457886) (0, 45.529168) (-7.5980953, 45.60045) (-15.231832, 45.671733) (-22.901211, 45.743016) (-30.606232, 45.814298) (-33.644479, 45.593384) (-36.568745, 44.799305) (-39.269405, 43.465318) (-41.645426, 41.645426) (-43.607883, 39.411971) (-45.084435, 36.853879) (-46.021079, 34.072181) (-46.384557, 31.176506) (-46.455839, 23.435842) (-46.527122, 15.659537) (-46.598405, 7.8475892) (-46.669687, 0) (-46.740969, -7.883232) (-46.812252, -15.802106) (-46.883535, -23.756621) (-46.954817, -31.746779) (-46.733903, -34.785019) (-45.939824, -37.709279) (-44.605837, -40.409932) (-42.785944, -42.785944) (-40.552498, -44.748402) (-37.994413, -46.224954) (-35.212722, -47.161597) (-32.317052, -47.525076) (-24.291251, -47.596358) (-16.229809, -47.667641) (-8.1327256, -47.738924) (0, -47.810206) (8.1683684, -47.881487) (16.372378, -47.95277) (24.61203, -48.024053) (32.887324, -48.095335) (35.925559, -47.874421) (38.849813, -47.080343) (41.550459, -45.746356) (43.926463, -43.926463) (45.88892, -41.693025) (47.365472, -39.134946) (48.302116, -36.353261) (48.665594, -33.457596) (48.736876, -25.14666) (48.808159, -16.800082) (48.879442, -8.4178617) (48.950724, 0) (49.022006, 8.4535044) (49.093289, 16.942651) (49.164572, 25.467438) (49.235854, 34.027868) (49.01494, 37.066098) (48.220861, 39.990346) (46.886874, 42.690985) (45.066982, 45.066982) (42.833551, 47.029439) (40.275479, 48.505991) (37.4938, 49.442634) (34.59814, 49.806113) (26.002067, 49.877395) (17.370353, 49.948678) (8.7029975, 50.019961) (0, 50.091243) (-8.7386402, 50.162525) (-17.512922, 50.233807) (-26.322846, 50.30509) (-35.168411, 50.376372) (-38.206636, 50.155458) (-41.130878, 49.36138) (-43.831511, 48.027393) (-46.2075, 46.2075) (-48.169958, 43.974077) (-49.646509, 41.416011) (-50.583153, 38.634337) (-50.946632, 35.738682) (-51.017914, 26.857474) (-51.089196, 17.940624) (-51.160479, 8.988133) (-51.231761, 0) (-51.303043, -9.0237757) (-51.374326, -18.083193) (-51.445609, -27.178252) (-51.516891, -36.308953) (-51.295977, -39.347172) (-50.501898, -42.27141) (-49.167911, -44.972037)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, section rectangle width=2mm height=0.5mm)
  Tx1.move(-60.196445mm, 0mm, 0mm)
  LD_Tx1_0_V = cylinder(axis=Z, base_centre=(-29.779148mm, -15.208649mm, 0.575mm), radius=0.3mm, height=1.425mm)
  LD_Tx1_0_H = cylinder(axis=Y, base_centre=(-29.779148mm, -134.94mm, 2mm), radius=0.3mm, height=120.03135mm)
  LD_Tx1_1_V = cylinder(axis=Z, base_centre=(24.602265mm, -72.850225mm, 0.575mm), radius=0.3mm, height=1.425mm)
  LD_Tx1_1_H = cylinder(axis=Y, base_centre=(24.602265mm, -134.94mm, 2mm), radius=0.3mm, height=62.389775mm)
  Tx1.unite(LD_Tx1_0_V, LD_Tx1_0_H, LD_Tx1_1_V, LD_Tx1_1_H)
  Tx2 [copper] = polyline(z=-0.325mm, xy in mm: (30.417297, -15.208649) (30.488579, -11.459951) (30.559862, -7.6756103) (30.631145, -3.8556266) (30.702427, 0) (30.773709, 3.8912706) (30.844992, 7.8181841) (30.916275, 11.780741) (30.987557, 15.77894) (30.766643, 18.817299) (29.972564, 21.741688) (28.638577, 24.44249) (26.818684, 26.818684) (24.585058, 28.781142) (22.026827, 30.257694) (19.245012, 31.194337) (16.34923, 31.557816) (12.315387, 31.629098) (8.2459006, 31.700381) (4.1407717, 31.771664) (0, 31.842946) (-4.1764155, 31.914227) (-8.3884739, 31.98551) (-12.636175, 32.056793) (-16.919519, 32.128075) (-19.957866, 31.907161) (-22.882242, 31.113083) (-25.583028, 29.779096) (-27.959203, 27.959203) (-29.92166, 25.725595) (-31.398212, 23.16738) (-32.334856, 20.385577) (-32.698334, 17.489807) (-32.769616, 13.170819) (-32.840899, 8.8161888) (-32.912182, 4.4259157) (-32.983464, 0) (-33.054746, -4.4615594) (-33.126029, -8.9587616) (-33.197312, -13.491606) (-33.268594, -18.060094) (-33.04768, -21.098429) (-32.253601, -24.022793) (-30.919614, -26.723565) (-29.099722, -29.099722) (-26.866132, -31.062179) (-24.30793, -32.538731) (-21.52614, -33.475374) (-18.63038, -33.838853) (-14.026249, -33.910135) (-9.386475, -33.981418) (-4.7110588, -34.052701) (0, -34.123983) (4.7467024, -34.195265) (9.5290473, -34.266547) (14.347035, -34.33783) (19.200665, -34.409112) (22.23899, -34.188198) (25.163342, -33.39412) (27.8641, -32.060133) (30.24024, -30.24024) (32.202698, -28.006667) (33.679249, -25.448478) (34.615893, -22.666699) (34.979372, -19.770949) (35.050653, -14.881676) (35.121936, -9.9567595) (35.193219, -4.996201) (35.264501, 0) (35.335783, 5.0318445) (35.407066, 10.099331) (35.478349, 15.202461) (35.549631, 20.341233) (35.328717, 23.379547) (34.534638, 26.303888) (33.200651, 29.004634) (31.380759, 31.380759) (29.147201, 33.343216) (26.589025, 34.819768) (23.807256, 35.756411) (20.911515, 36.11989) (15.7371, 36.191172) (10.527042, 36.262455) (5.2813424, 36.333738) (0, 36.40502) (-5.3169858, 36.476302) (-10.669614, 36.547585) (-16.057884, 36.618868) (-21.481797, 36.690149) (-24.520103, 36.469236) (-27.444433, 35.675157) (-30.145167, 34.34117) (-32.521277, 32.521277) (-34.483735, 30.287734) (-35.960286, 27.729569) (-36.89693, 24.94781) (-37.260409, 22.052079) (-37.331691, 16.592522) (-37.402974, 11.097324) (-37.474256, 5.5664831) (-37.545538, 0) (-37.61682, -5.6021264) (-37.688103, -11.239895) (-37.759386, -16.913306) (-37.830668, -22.622359) (-37.609754, -25.660656) (-36.815675, -28.584977) (-35.481688, -31.2857) (-33.661796, -33.661796) (-31.428266, -35.624253) (-28.870112, -37.100805) (-26.088362, -38.037449) (-23.192639, -38.400927) (-17.447943, -38.472209) (-11.667604, -38.543492) (-5.8516231, -38.614775) (0, -38.686057) (5.8872664, -38.757339) (11.810175, -38.828622) (17.768726, -38.899905) (23.762919, -38.971187) (26.801207, -38.750273) (29.725519, -37.956194) (32.426231, -36.622207) (34.802314, -34.802314) (36.764772, -32.568797) (38.241324, -30.010654) (39.177967, -27.228913) (39.541446, -24.333197) (39.612728, -18.303361) (39.684011, -12.237883) (39.755294, -6.1367626) (39.826576, 0) (39.897857, 6.1724057) (39.96914, 12.380454) (40.040423, 18.624144) (40.111705, 24.903476) (39.890791, 27.941756) (39.096713, 30.866059) (37.762726, 33.566762) (35.942833, 35.942833) (33.709328, 37.90529) (31.151194, 39.381842) (28.369461, 40.318486) (25.473753, 40.681964) (19.158778, 40.753246) (12.808161, 40.824529) (6.4219015, 40.895812) (0, 40.967094) (-6.4575446, 41.038376) (-12.950731, 41.109659) (-19.47956, 41.180942) (-26.044031, 41.252224) (-29.082303, 41.03131) (-32.006598, 40.237231) (-34.707291, 38.903244) (-37.083352, 37.083352) (-39.045809, 34.849858) (-40.522361, 32.291733) (-41.459004, 29.510008) (-41.822483, 26.614307) (-41.893765, 20.014194) (-41.965048, 13.378438) (-42.036331, 6.7070399) (-42.107613, 0) (-42.178895, -6.7426829) (-42.250177, -13.521008) (-42.32146, -20.334975) (-42.392742, -27.184584) (-42.171828, -30.222849) (-41.37775, -33.147137) (-40.043763, -35.847821) (-38.22387, -38.22387) (-35.990387, -40.186328) (-33.432271, -41.662879) (-30.650553, -42.599523) (-27.754859, -42.963002) (-20.869608, -43.034283) (-13.948714, -43.105566) (-6.9921778, -43.176849) (0, -43.248131) (7.0278208, -43.319413) (14.091284, -43.390696) (21.190388, -43.461979) (28.325135, -43.533261) (31.363394, -43.312347) (34.287674, -42.518268) (36.988349, -41.184281) (39.364389, -39.364389) (41.326846, -37.130915) (42.803398, -34.572808) (43.740041, -31.791097) (44.10352, -28.89541) (44.174802, -21.72502) (44.246085, -14.518989) (44.317368, -7.2773153) (44.38865, 0) (44.459932, 7.3129582) (44.531215, 14.661558) (44.602498, 22.0458) (44.673779, 29.465684) (44.452866, 32.503937) (43.658787, 35.42821) (42.3248, 38.128877) (40.504907, 40.504907) (38.271443, 42.467365) (35.713344, 43.943917) (32.93164, 44.88056) (30.035958, 45.244039) (22.580432, 45.315321) (15.089263, 45.386604) (7.5624524, 45.457886) (0, 45.529168) (-7.5980953, 45.60045) (-15.231832, 45.671733) (-22.901211, 45.743016) (-30.606232, 45.814298) (-33.644479, 45.593384) (-36.568745, 44.799305) (-39.269405, 43.465318) (-41.645426, 41.645426) (-43.607883, 39.411971) (-45.084435, 36.853879) (-46.021079, 34.072181) (-46.384557, 31.176506) (-46.455839, 23.435842) (-46.527122, 15.659537) (-46.598405, 7.8475892) (-46.669687, 0) (-46.740969, -7.883232) (-46.812252, -15.802106) (-46.883535, -23.756621) (-46.954817, -31.746779) (-46.733903, -34.785019) (-45.939824, -37.709279) (-44.605837, -40.409932) (-42.785944, -42.785944) (-40.552498, -44.748402) (-37.994413, -46.224954) (-35.212722, -47.161597) (-32.317052, -47.525076) (-24.291251, -47.596358) (-16.229809, -47.667641) (-8.1327256, -47.738924) (0, -47.810206) (8.1683684, -47.881487) (16.372378, -47.95277) (24.61203, -48.024053) (32.887324, -48.095335) (35.925559, -47.874421) (38.849813, -47.080343) (41.550459, -45.746356) (43.926463, -43.926463) (45.88892, -41.693025) (47.365472, -39.134946) (48.302116, -36.353261) (48.665594, -33.457596) (48.736876, -25.14666) (48.808159, -16.800082) (48.879442, -8.4178617) (48.950724, 0) (49.022006, 8.4535044) (49.093289, 16.942651) (49.164572, 25.467438) (49.235854, 34.027868) (49.01494, 37.066098) (48.220861, 39.990346) (46.886874, 42.690985) (45.066982, 45.066982) (42.833551, 47.029439) (40.275479, 48.505991) (37.4938, 49.442634) (34.59814, 49.806113) (26.002067, 49.877395) (17.370353, 49.948678) (8.7029975, 50.019961) (0, 50.091243) (-8.7386402, 50.162525) (-17.512922, 50.233807) (-26.322846, 50.30509) (-35.168411, 50.376372) (-38.206636, 50.155458) (-41.130878, 49.36138) (-43.831511, 48.027393) (-46.2075, 46.2075) (-48.169958, 43.974077) (-49.646509, 41.416011) (-50.583153, 38.634337) (-50.946632, 35.738682) (-51.017914, 26.857474) (-51.089196, 17.940624) (-51.160479, 8.988133) (-51.231761, 0) (-51.303043, -9.0237757) (-51.374326, -18.083193) (-51.445609, -27.178252) (-51.516891, -36.308953) (-51.295977, -39.347172) (-50.501898, -42.27141) (-49.167911, -44.972037)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, section rectangle width=2mm height=0.5mm)
  Tx2.move(58.901585mm, 0mm, 0mm)
  LD_Tx2_0_V = cylinder(axis=Z, base_centre=(89.318882mm, -15.208649mm, -2mm), radius=0.3mm, height=1.425mm)
  LD_Tx2_0_H = cylinder(axis=Y, base_centre=(89.318882mm, -134.94mm, -2mm), radius=0.3mm, height=120.03135mm)
  LD_Tx2_1_V = cylinder(axis=Z, base_centre=(143.70029mm, -72.850225mm, -2mm), radius=0.3mm, height=1.425mm)
  LD_Tx2_1_H = cylinder(axis=Y, base_centre=(143.70029mm, -134.94mm, -2mm), radius=0.3mm, height=62.389775mm)
  Tx2.unite(LD_Tx2_0_V, LD_Tx2_0_H, LD_Tx2_1_V, LD_Tx2_1_H)
  Rx [copper] = polyline(z=30mm, xy in mm: (30.417297, -15.208649) (30.488579, -11.459951) (30.559862, -7.6756103) (30.631145, -3.8556266) (30.702427, 0) (30.773709, 3.8912706) (30.844992, 7.8181841) (30.916275, 11.780741) (30.987557, 15.77894) (30.766643, 18.817299) (29.972564, 21.741688) (28.638577, 24.44249) (26.818684, 26.818684) (24.585058, 28.781142) (22.026827, 30.257694) (19.245012, 31.194337) (16.34923, 31.557816) (12.315387, 31.629098) (8.2459006, 31.700381) (4.1407717, 31.771664) (0, 31.842946) (-4.1764155, 31.914227) (-8.3884739, 31.98551) (-12.636175, 32.056793) (-16.919519, 32.128075) (-19.957866, 31.907161) (-22.882242, 31.113083) (-25.583028, 29.779096) (-27.959203, 27.959203) (-29.92166, 25.725595) (-31.398212, 23.16738) (-32.334856, 20.385577) (-32.698334, 17.489807) (-32.769616, 13.170819) (-32.840899, 8.8161888) (-32.912182, 4.4259157) (-32.983464, 0) (-33.054746, -4.4615594) (-33.126029, -8.9587616) (-33.197312, -13.491606) (-33.268594, -18.060094) (-33.04768, -21.098429) (-32.253601, -24.022793) (-30.919614, -26.723565) (-29.099722, -29.099722) (-26.866132, -31.062179) (-24.30793, -32.538731) (-21.52614, -33.475374) (-18.63038, -33.838853) (-14.026249, -33.910135) (-9.386475, -33.981418) (-4.7110588, -34.052701) (0, -34.123983) (4.7467024, -34.195265) (9.5290473, -34.266547) (14.347035, -34.33783) (19.200665, -34.409112) (22.23899, -34.188198) (25.163342, -33.39412) (27.8641, -32.060133) (30.24024, -30.24024) (32.202698, -28.006667) (33.679249, -25.448478) (34.615893, -22.666699) (34.979372, -19.770949) (35.050653, -14.881676) (35.121936, -9.9567595) (35.193219, -4.996201) (35.264501, 0) (35.335783, 5.0318445) (35.407066, 10.099331) (35.478349, 15.202461) (35.549631, 20.341233) (35.328717, 23.379547) (34.534638, 26.303888) (33.200651, 29.004634) (31.380759, 31.380759) (29.147201, 33.343216) (26.589025, 34.819768) (23.807256, 35.756411) (20.911515, 36.11989) (15.7371, 36.191172) (10.527042, 36.262455) (5.2813424, 36.333738) (0, 36.40502) (-5.3169858, 36.476302) (-10.669614, 36.547585) (-16.057884, 36.618868) (-21.481797, 36.690149) (-24.520103, 36.469236) (-27.444433, 35.675157) (-30.145167, 34.34117) (-32.521277, 32.521277) (-34.483735, 30.287734) (-35.960286, 27.729569) (-36.89693, 24.94781) (-37.260409, 22.052079) (-37.331691, 16.592522) (-37.402974, 11.097324) (-37.474256, 5.5664831) (-37.545538, 0) (-37.61682, -5.6021264) (-37.688103, -11.239895) (-37.759386, -16.913306) (-37.830668, -22.622359) (-37.609754, -25.660656) (-36.815675, -28.584977) (-35.481688, -31.2857) (-33.661796, -33.661796) (-31.428266, -35.624253) (-28.870112, -37.100805) (-26.088362, -38.037449) (-23.192639, -38.400927) (-17.447943, -38.472209) (-11.667604, -38.543492) (-5.8516231, -38.614775) (0, -38.686057) (5.8872664, -38.757339) (11.810175, -38.828622) (17.768726, -38.899905) (23.762919, -38.971187) (26.801207, -38.750273) (29.725519, -37.956194) (32.426231, -36.622207) (34.802314, -34.802314) (36.764772, -32.568797) (38.241324, -30.010654) (39.177967, -27.228913) (39.541446, -24.333197) (39.612728, -18.303361) (39.684011, -12.237883) (39.755294, -6.1367626) (39.826576, 0) (39.897857, 6.1724057) (39.96914, 12.380454) (40.040423, 18.624144) (40.111705, 24.903476) (39.890791, 27.941756) (39.096713, 30.866059) (37.762726, 33.566762) (35.942833, 35.942833) (33.709328, 37.90529) (31.151194, 39.381842) (28.369461, 40.318486) (25.473753, 40.681964) (19.158778, 40.753246) (12.808161, 40.824529) (6.4219015, 40.895812) (0, 40.967094) (-6.4575446, 41.038376) (-12.950731, 41.109659) (-19.47956, 41.180942) (-26.044031, 41.252224) (-29.082303, 41.03131) (-32.006598, 40.237231) (-34.707291, 38.903244) (-37.083352, 37.083352) (-39.045809, 34.849858) (-40.522361, 32.291733) (-41.459004, 29.510008) (-41.822483, 26.614307) (-41.893765, 20.014194) (-41.965048, 13.378438) (-42.036331, 6.7070399) (-42.107613, 0) (-42.178895, -6.7426829) (-42.250177, -13.521008) (-42.32146, -20.334975) (-42.392742, -27.184584) (-42.171828, -30.222849) (-41.37775, -33.147137) (-40.043763, -35.847821) (-38.22387, -38.22387) (-35.990387, -40.186328) (-33.432271, -41.662879) (-30.650553, -42.599523) (-27.754859, -42.963002) (-20.869608, -43.034283) (-13.948714, -43.105566) (-6.9921778, -43.176849) (0, -43.248131) (7.0278208, -43.319413) (14.091284, -43.390696) (21.190388, -43.461979) (28.325135, -43.533261) (31.363394, -43.312347) (34.287674, -42.518268) (36.988349, -41.184281) (39.364389, -39.364389) (41.326846, -37.130915) (42.803398, -34.572808) (43.740041, -31.791097) (44.10352, -28.89541) (44.174802, -21.72502) (44.246085, -14.518989) (44.317368, -7.2773153) (44.38865, 0) (44.459932, 7.3129582) (44.531215, 14.661558) (44.602498, 22.0458) (44.673779, 29.465684) (44.452866, 32.503937) (43.658787, 35.42821) (42.3248, 38.128877) (40.504907, 40.504907) (38.271443, 42.467365) (35.713344, 43.943917) (32.93164, 44.88056) (30.035958, 45.244039) (22.580432, 45.315321) (15.089263, 45.386604) (7.5624524, 45.457886) (0, 45.529168) (-7.5980953, 45.60045) (-15.231832, 45.671733) (-22.901211, 45.743016) (-30.606232, 45.814298) (-33.644479, 45.593384) (-36.568745, 44.799305) (-39.269405, 43.465318) (-41.645426, 41.645426) (-43.607883, 39.411971) (-45.084435, 36.853879) (-46.021079, 34.072181) (-46.384557, 31.176506) (-46.455839, 23.435842) (-46.527122, 15.659537) (-46.598405, 7.8475892) (-46.669687, 0) (-46.740969, -7.883232) (-46.812252, -15.802106) (-46.883535, -23.756621) (-46.954817, -31.746779) (-46.733903, -34.785019) (-45.939824, -37.709279) (-44.605837, -40.409932) (-42.785944, -42.785944) (-40.552498, -44.748402) (-37.994413, -46.224954) (-35.212722, -47.161597) (-32.317052, -47.525076) (-24.291251, -47.596358) (-16.229809, -47.667641) (-8.1327256, -47.738924) (0, -47.810206) (8.1683684, -47.881487) (16.372378, -47.95277) (24.61203, -48.024053) (32.887324, -48.095335) (35.925559, -47.874421) (38.849813, -47.080343) (41.550459, -45.746356) (43.926463, -43.926463) (45.88892, -41.693025) (47.365472, -39.134946) (48.302116, -36.353261) (48.665594, -33.457596) (48.736876, -25.14666) (48.808159, -16.800082) (48.879442, -8.4178617) (48.950724, 0) (49.022006, 8.4535044) (49.093289, 16.942651) (49.164572, 25.467438) (49.235854, 34.027868) (49.01494, 37.066098) (48.220861, 39.990346) (46.886874, 42.690985) (45.066982, 45.066982) (42.833551, 47.029439) (40.275479, 48.505991) (37.4938, 49.442634) (34.59814, 49.806113) (26.002067, 49.877395) (17.370353, 49.948678) (8.7029975, 50.019961) (0, 50.091243) (-8.7386402, 50.162525) (-17.512922, 50.233807) (-26.322846, 50.30509) (-35.168411, 50.376372) (-38.206636, 50.155458) (-41.130878, 49.36138) (-43.831511, 48.027393) (-46.2075, 46.2075) (-48.169958, 43.974077) (-49.646509, 41.416011) (-50.583153, 38.634337) (-50.946632, 35.738682) (-51.017914, 26.857474) (-51.089196, 17.940624) (-51.160479, 8.988133) (-51.231761, 0) (-51.303043, -9.0237757) (-51.374326, -18.083193) (-51.445609, -27.178252) (-51.516891, -36.308953) (-51.295977, -39.347172) (-50.501898, -42.27141) (-49.167911, -44.972037)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, section rectangle width=2mm height=0.5mm)
  Rx.move(-0.64743039mm, 0mm, 0mm)
  LD_Rx_0_V = cylinder(axis=Z, base_centre=(29.769867mm, -15.208649mm, 30.25mm), radius=0.3mm, height=44.75mm)
  LD_Rx_1_V = cylinder(axis=Z, base_centre=(84.15128mm, -72.850225mm, 30.25mm), radius=0.3mm, height=44.75mm)
  Rx.unite(LD_Rx_0_V, LD_Rx_1_V)
  ferrite_Tx_0 [ferrite] = box(corner=(-155mm, -83.99995mm, -40mm), size=(10mm, 167.9999mm, 10mm))
  ferrite_Tx_1 [ferrite] = box(corner=(-125mm, -83.99995mm, -40mm), size=(10mm, 167.9999mm, 10mm))
  ferrite_Tx_2 [ferrite] = box(corner=(-95mm, -83.99995mm, -40mm), size=(10mm, 167.9999mm, 10mm))
  ferrite_Tx_3 [ferrite] = box(corner=(-65mm, -83.99995mm, -40mm), size=(10mm, 167.9999mm, 10mm))
  ferrite_Tx_4 [ferrite] = box(corner=(-35mm, -83.99995mm, -40mm), size=(10mm, 167.9999mm, 10mm))
  ferrite_Tx_5 [ferrite] = box(corner=(-5mm, -83.99995mm, -40mm), size=(10mm, 167.9999mm, 10mm))
  ferrite_Tx_6 [ferrite] = box(corner=(25mm, -83.99995mm, -40mm), size=(10mm, 167.9999mm, 10mm))
  ferrite_Tx_7 [ferrite] = box(corner=(55mm, -83.99995mm, -40mm), size=(10mm, 167.9999mm, 10mm))
  ferrite_Tx_8 [ferrite] = box(corner=(85mm, -83.99995mm, -40mm), size=(10mm, 167.9999mm, 10mm))
  ferrite_Tx_9 [ferrite] = box(corner=(115mm, -83.99995mm, -40mm), size=(10mm, 167.9999mm, 10mm))
  ferrite_Tx_10 [ferrite] = box(corner=(145mm, -83.99995mm, -40mm), size=(10mm, 167.9999mm, 10mm))
  ferrite_Rx_0 [ferrite] = box(corner=(-95mm, -83.99995mm, 60mm), size=(10mm, 167.9999mm, 10mm))
  ferrite_Rx_1 [ferrite] = box(corner=(-65mm, -83.99995mm, 60mm), size=(10mm, 167.9999mm, 10mm))
  ferrite_Rx_2 [ferrite] = box(corner=(-35mm, -83.99995mm, 60mm), size=(10mm, 167.9999mm, 10mm))
  ferrite_Rx_3 [ferrite] = box(corner=(-5mm, -83.99995mm, 60mm), size=(10mm, 167.9999mm, 10mm))
  ferrite_Rx_4 [ferrite] = box(corner=(25mm, -83.99995mm, 60mm), size=(10mm, 167.9999mm, 10mm))
  ferrite_Rx_5 [ferrite] = box(corner=(55mm, -83.99995mm, 60mm), size=(10mm, 167.9999mm, 10mm))
  ferrite_Rx_6 [ferrite] = box(corner=(85mm, -83.99995mm, 60mm), size=(10mm, 167.9999mm, 10mm))
  aux_hole = cylinder(axis=Z, base_centre=(29.7699mm, -15.2086mm, 30mm), radius=1mm, height=45mm)
  ferrite_Rx_4.subtract(aux_hole)
  Region [air] = region(absolute_offset: +X=175mm, -X=175mm, +Y=77.0001mm, -Y=0mm, +Z=0mm, -Z=5mm)
  [Rx, ferrite_Rx_0..ferrite_Rx_6].move(0.05mm, 0mm, 0mm)
  [Rx, ferrite_Rx_0..ferrite_Rx_6].move(-0.05mm, 0mm, 0mm)
  [Rx, ferrite_Rx_0..ferrite_Rx_6].move(0.05mm, 0mm, 0mm)
  [Rx, ferrite_Rx_0..ferrite_Rx_6].move(-0.05mm, 0mm, 0mm)
boundaries and excitations:
  CT_Tx1_N: Coil Terminal Faces=Tx1.face(at (-29.7791, -134.94, 2)) Conductor_number=1 Winding=Winding_Tx1 Point_out_of_terminal=true
  CT_Tx1_P: Coil Terminal Faces=Tx1.face(at (24.6023, -134.94, 2)) Conductor_number=1 Winding=Winding_Tx1 Point_out_of_terminal=false
  CT_Tx2_N: Coil Terminal Faces=Tx2.face(at (89.3189, -134.94, -2)) Conductor_number=1 Winding=Winding_Tx2 Point_out_of_terminal=true
  CT_Tx2_P: Coil Terminal Faces=Tx2.face(at (143.7, -134.94, -2)) Conductor_number=1 Winding=Winding_Tx2 Point_out_of_terminal=false
  CT_Rx_N: Coil Terminal Faces=Rx.face(at (29.7699, -15.2086, 75)) Conductor_number=1 Winding=Winding_Rx Point_out_of_terminal=true
  CT_Rx_P: Coil Terminal Faces=Rx.face(at (84.1513, -72.8502, 75)) Conductor_number=1 Winding=Winding_Rx Point_out_of_terminal=false
  Winding_Tx1: Winding Group Type=Current IsSolid=false Current=10A ParallelBranchesNum=1
  Winding_Tx2: Winding Group Type=Current IsSolid=false Current=10A ParallelBranchesNum=1
  Winding_Rx: Winding Group Type=Current IsSolid=false Current=0A ParallelBranchesNum=1
parameters:
  Lmatrix: Matrix Winding_Tx1, Winding_Tx2, Winding_Rx: NumberOfTurns=1
mesh:
  region_coarse: LengthBased RefineInside Objects=Region MaxLength=33.4566mm
  initial mesh: DynamicSurfaceResolution UseFlexMeshingForTAUvolumeMesh
setups:
  Setup1: Magnetostatic MaximumPasses=8 MinimumPasses=2 MinimumConvergedPasses=1 PercentRefinement=10 PercentError=5 RelativeResidual=1e-06 NonLinearResidual=0.001
