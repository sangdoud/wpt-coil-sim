# Ansys Electronics Desktop project, version 2024.1
materials:
  vacuum: permittivity=1
  copper: permeability=0.999991 conductivity=58000000
  ferrite: permittivity=12 permeability=1000
  air: permittivity=1.0006 permeability=1.0000004
surface materials:
  Steel-oxidised-surface

design WPT_F (Maxwell 3D, EddyCurrent, model units mm)
geometry:
  Tx1 [copper] = polyline(z=0mm, xy in mm: (-56, -15) (-55.929688, -11.302734) (-55.859375, -7.570312) (-55.789062, -3.802734) (-55.71875, 0) (-55.648438, 3.837891) (-55.578125, 7.710938) (-55.507812, 11.619141) (-55.4375, 15.5625) (-55.655408, 18.559167) (-56.438682, 21.443376) (-57.754518, 24.106991) (-59.549648, 26.450352) (-61.752384, 28.386107) (-64.275374, 29.842568) (-67.018958, 30.766467) (-69.875, 31.125) (-73.853516, 31.195312) (-77.867188, 31.265625) (-81.916016, 31.335938) (-86, 31.40625) (-90.119141, 31.476562) (-94.273438, 31.546875) (-98.462891, 31.617188) (-102.6875, 31.6875) (-105.684167, 31.469592) (-108.568376, 30.686318) (-111.231991, 29.370482) (-113.575352, 27.575352) (-115.511107, 25.372616) (-116.967568, 22.849626) (-117.891467, 20.106042) (-118.25, 17.25) (-118.320312, 12.990234) (-118.390625, 8.695312) (-118.460938, 4.365234) (-118.53125, 0) (-118.601562, -4.400391) (-118.671875, -8.835938) (-118.742188, -13.306641) (-118.8125, -17.8125) (-118.594592, -20.809167) (-117.811318, -23.693376) (-116.495482, -26.356991) (-114.700352, -28.700352) (-112.497616, -30.636107) (-109.974626, -32.092568) (-107.231042, -33.016467) (-104.375, -33.375) (-99.833984, -33.445312) (-95.257812, -33.515625) (-90.646484, -33.585938) (-86, -33.65625) (-81.318359, -33.726562) (-76.601562, -33.796875) (-71.849609, -33.867188) (-67.0625, -33.9375) (-64.065833, -33.719592) (-61.181624, -32.936318) (-58.518009, -31.620482) (-56.174648, -29.825352) (-54.238893, -27.622616) (-52.782432, -25.099626) (-51.858533, -22.356042) (-51.5, -19.5) (-51.429688, -14.677734) (-51.359375, -9.820312) (-51.289062, -4.927734) (-51.21875, 0) (-51.148438, 4.962891) (-51.078125, 9.960938) (-51.007812, 14.994141) (-50.9375, 20.0625) (-51.155408, 23.059167) (-51.938682, 25.943376) (-53.254518, 28.606991) (-55.049648, 30.950352) (-57.252384, 32.886107) (-59.775374, 34.342568) (-62.518958, 35.266467) (-65.375, 35.625) (-70.478516, 35.695312) (-75.617188, 35.765625) (-80.791016, 35.835938) (-86, 35.90625) (-91.244141, 35.976562) (-96.523438, 36.046875) (-101.837891, 36.117188) (-107.1875, 36.1875) (-110.184167, 35.969592) (-113.068376, 35.186318) (-115.731991, 33.870482) (-118.075352, 32.075352) (-120.011107, 29.872616) (-121.467568, 27.349626) (-122.391467, 24.606042) (-122.75, 21.75) (-122.820312, 16.365234) (-122.890625, 10.945312) (-122.960938, 5.490234) (-123.03125, 0) (-123.101562, -5.525391) (-123.171875, -11.085938) (-123.242188, -16.681641) (-123.3125, -22.3125) (-123.094592, -25.309167) (-122.311318, -28.193376) (-120.995482, -30.856991) (-119.200352, -33.200352) (-116.997616, -35.136107) (-114.474626, -36.592568) (-111.731042, -37.516467) (-108.875, -37.875) (-103.208984, -37.945312) (-97.507812, -38.015625) (-91.771484, -38.085938) (-86, -38.15625) (-80.193359, -38.226562) (-74.351562, -38.296875) (-68.474609, -38.367188) (-62.5625, -38.4375) (-59.565833, -38.219592) (-56.681624, -37.436318) (-54.018009, -36.120482) (-51.674648, -34.325352) (-49.738893, -32.122616) (-48.282432, -29.599626) (-47.358533, -26.856042) (-47, -24) (-46.929688, -18.052734) (-46.859375, -12.070312) (-46.789062, -6.052734) (-46.71875, 0) (-46.648438, 6.087891) (-46.578125, 12.210938) (-46.507812, 18.369141) (-46.4375, 24.5625) (-46.655408, 27.559167) (-47.438682, 30.443376) (-48.754518, 33.106991) (-50.549648, 35.450352) (-52.752384, 37.386107) (-55.275374, 38.842568) (-58.018958, 39.766467) (-60.875, 40.125) (-67.103516, 40.195312) (-73.367188, 40.265625) (-79.666016, 40.335938) (-86, 40.40625) (-92.369141, 40.476562) (-98.773438, 40.546875) (-105.212891, 40.617188) (-111.6875, 40.6875) (-114.684167, 40.469592) (-117.568376, 39.686318) (-120.231991, 38.370482) (-122.575352, 36.575352) (-124.511107, 34.372616) (-125.967568, 31.849626) (-126.891467, 29.106042) (-127.25, 26.25) (-127.320312, 19.740234) (-127.390625, 13.195312) (-127.460938, 6.615234) (-127.53125, 0) (-127.601562, -6.650391) (-127.671875, -13.335938) (-127.742188, -20.056641) (-127.8125, -26.8125) (-127.594592, -29.809167) (-126.811318, -32.693376) (-125.495482, -35.356991) (-123.700352, -37.700352) (-121.497616, -39.636107) (-118.974626, -41.092568) (-116.231042, -42.016467) (-113.375, -42.375) (-106.583984, -42.445312) (-99.757812, -42.515625) (-92.896484, -42.585938) (-86, -42.65625) (-79.068359, -42.726562) (-72.101562, -42.796875) (-65.099609, -42.867188) (-58.0625, -42.9375) (-55.065833, -42.719592) (-52.181624, -41.936318) (-49.518009, -40.620482) (-47.174648, -38.825352) (-45.238893, -36.622616) (-43.782432, -34.099626) (-42.858533, -31.356042) (-42.5, -28.5) (-42.429688, -21.427734) (-42.359375, -14.320312) (-42.289062, -7.177734) (-42.21875, 0) (-42.148438, 7.212891) (-42.078125, 14.460938) (-42.007812, 21.744141) (-41.9375, 29.0625) (-42.155408, 32.059167) (-42.938682, 34.943376) (-44.254518, 37.606991) (-46.049648, 39.950352) (-48.252384, 41.886107) (-50.775374, 43.342568) (-53.518958, 44.266467) (-56.375, 44.625) (-63.728516, 44.695312) (-71.117188, 44.765625) (-78.541016, 44.835938) (-86, 44.90625) (-93.494141, 44.976562) (-101.023438, 45.046875) (-108.587891, 45.117188) (-116.1875, 45.1875) (-119.184167, 44.969592) (-122.068376, 44.186318) (-124.731991, 42.870482) (-127.075352, 41.075352) (-129.011107, 38.872616) (-130.467568, 36.349626) (-131.391467, 33.606042) (-131.75, 30.75) (-131.820312, 23.115234) (-131.890625, 15.445312) (-131.960938, 7.740234) (-132.03125, 0) (-132.101562, -7.775391) (-132.171875, -15.585938) (-132.242188, -23.431641) (-132.3125, -31.3125) (-132.094592, -34.309167) (-131.311318, -37.193376) (-129.995482, -39.856991) (-128.200352, -42.200352) (-125.997616, -44.136107) (-123.474626, -45.592568) (-120.731042, -46.516467) (-117.875, -46.875) (-109.958984, -46.945312) (-102.007812, -47.015625) (-94.021484, -47.085938) (-86, -47.15625) (-77.943359, -47.226562) (-69.851562, -47.296875) (-61.724609, -47.367188) (-53.5625, -47.4375) (-50.565833, -47.219592) (-47.681624, -46.436318) (-45.018009, -45.120482) (-42.674648, -43.325352) (-40.738893, -41.122616) (-39.282432, -38.599626) (-38.358533, -35.856042) (-38, -33) (-37.929688, -24.802734) (-37.859375, -16.570312) (-37.789062, -8.302734) (-37.71875, 0) (-37.648438, 8.337891) (-37.578125, 16.710938) (-37.507812, 25.119141) (-37.4375, 33.5625) (-37.655408, 36.559167) (-38.438682, 39.443376) (-39.754518, 42.106991) (-41.549648, 44.450352) (-43.752384, 46.386107) (-46.275374, 47.842568) (-49.018958, 48.766467) (-51.875, 49.125) (-60.353516, 49.195312) (-68.867188, 49.265625) (-77.416016, 49.335938) (-86, 49.40625) (-94.619141, 49.476562) (-103.273438, 49.546875) (-111.962891, 49.617188) (-120.6875, 49.6875) (-123.684167, 49.469592) (-126.568376, 48.686318) (-129.231991, 47.370482) (-131.575352, 45.575352) (-133.511107, 43.372616) (-134.967568, 40.849626) (-135.891467, 38.106042) (-136.25, 35.25) (-136.320312, 26.490234) (-136.390625, 17.695312) (-136.460938, 8.865234) (-136.53125, 0) (-136.601562, -8.900391) (-136.671875, -17.835938) (-136.742188, -26.806641) (-136.8125, -35.8125) (-136.594592, -38.809167) (-135.811318, -41.693376) (-134.495482, -44.356991)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, section rectangle width=3mm height=0.5mm)
  Tx2 [copper] = polyline(z=0mm, xy in mm: (116, -15) (116.070312, -11.302734) (116.140625, -7.570312) (116.210938, -3.802734) (116.28125, 0) (116.351562, 3.837891) (116.421875, 7.710938) (116.492188, 11.619141) (116.5625, 15.5625) (116.344592, 18.559167) (115.561318, 21.443376) (114.245482, 24.106991) (112.450352, 26.450352) (110.247616, 28.386107) (107.724626, 29.842568) (104.981042, 30.766467) (102.125, 31.125) (98.146484, 31.195312) (94.132812, 31.265625) (90.083984, 31.335938) (86, 31.40625) (81.880859, 31.476562) (77.726562, 31.546875) (73.537109, 31.617188) (69.3125, 31.6875) (66.315833, 31.469592) (63.431624, 30.686318) (60.768009, 29.370482) (58.424648, 27.575352) (56.488893, 25.372616) (55.032432, 22.849626) (54.108533, 20.106042) (53.75, 17.25) (53.679688, 12.990234) (53.609375, 8.695312) (53.539062, 4.365234) (53.46875, 0) (53.398438, -4.400391) (53.328125, -8.835938) (53.257812, -13.306641) (53.1875, -17.8125) (53.405408, -20.809167) (54.188682, -23.693376) (55.504518, -26.356991) (57.299648, -28.700352) (59.502384, -30.636107) (62.025374, -32.092568) (64.768958, -33.016467) (67.625, -33.375) (72.166016, -33.445312) (76.742188, -33.515625) (81.353516, -33.585938) (86, -33.65625) (90.681641, -33.726562) (95.398438, -33.796875) (100.150391, -33.867188) (104.9375, -33.9375) (107.934167, -33.719592) (110.818376, -32.936318) (113.481991, -31.620482) (115.825352, -29.825352) (117.761107, -27.622616) (119.217568, -25.099626) (120.141467, -22.356042) (120.5, -19.5) (120.570312, -14.677734) (120.640625, -9.820312) (120.710938, -4.927734) (120.78125, 0) (120.851562, 4.962891) (120.921875, 9.960938) (120.992188, 14.994141) (121.0625, 20.0625) (120.844592, 23.059167) (120.061318, 25.943376) (118.745482, 28.606991) (116.950352, 30.950352) (114.747616, 32.886107) (112.224626, 34.342568) (109.481042, 35.266467) (106.625, 35.625) (101.521484, 35.695312) (96.382812, 35.765625) (91.208984, 35.835938) (86, 35.90625) (80.755859, 35.976562) (75.476562, 36.046875) (70.162109, 36.117188) (64.8125, 36.1875) (61.815833, 35.969592) (58.931624, 35.186318) (56.268009, 33.870482) (53.924648, 32.075352) (51.988893, 29.872616) (50.532432, 27.349626) (49.608533, 24.606042) (49.25, 21.75) (49.179688, 16.365234) (49.109375, 10.945312) (49.039062, 5.490234) (48.96875, 0) (48.898438, -5.525391) (48.828125, -11.085938) (48.757812, -16.681641) (48.6875, -22.3125) (48.905408, -25.309167) (49.688682, -28.193376) (51.004518, -30.856991) (52.799648, -33.200352) (55.002384, -35.136107) (57.525374, -36.592568) (60.268958, -37.516467) (63.125, -37.875) (68.791016, -37.945312) (74.492188, -38.015625) (80.228516, -38.085938) (86, -38.15625) (91.806641, -38.226562) (97.648438, -38.296875) (103.525391, -38.367188) (109.4375, -38.4375) (112.434167, -38.219592) (115.318376, -37.436318) (117.981991, -36.120482) (120.325352, -34.325352) (122.261107, -32.122616) (123.717568, -29.599626) (124.641467, -26.856042) (125, -24) (125.070312, -18.052734) (125.140625, -12.070312) (125.210938, -6.052734) (125.28125, 0) (125.351562, 6.087891) (125.421875, 12.210938) (125.492188, 18.369141) (125.5625, 24.5625) (125.344592, 27.559167) (124.561318, 30.443376) (123.245482, 33.106991) (121.450352, 35.450352) (119.247616, 37.386107) (116.724626, 38.842568) (113.981042, 39.766467) (111.125, 40.125) (104.896484, 40.195312) (98.632812, 40.265625) (92.333984, 40.335938) (86, 40.40625) (79.630859, 40.476562) (73.226562, 40.546875) (66.787109, 40.617188) (60.3125, 40.6875) (57.315833, 40.469592) (54.431624, 39.686318) (51.768009, 38.370482) (49.424648, 36.575352) (47.488893, 34.372616) (46.032432, 31.849626) (45.108533, 29.106042) (44.75, 26.25) (44.679688, 19.740234) (44.609375, 13.195312) (44.539062, 6.615234) (44.46875, 0) (44.398438, -6.650391) (44.328125, -13.335938) (44.257812, -20.056641) (44.1875, -26.8125) (44.405408, -29.809167) (45.188682, -32.693376) (46.504518, -35.356991) (48.299648, -37.700352) (50.502384, -39.636107) (53.025374, -41.092568) (55.768958, -42.016467) (58.625, -42.375) (65.416016, -42.445312) (72.242188, -42.515625) (79.103516, -42.585938) (86, -42.65625) (92.931641, -42.726562) (99.898438, -42.796875) (106.900391, -42.867188) (113.9375, -42.9375) (116.934167, -42.719592) (119.818376, -41.936318) (122.481991, -40.620482) (124.825352, -38.825352) (126.761107, -36.622616) (128.217568, -34.099626) (129.141467, -31.356042) (129.5, -28.5) (129.570312, -21.427734) (129.640625, -14.320312) (129.710938, -7.177734) (129.78125, 0) (129.851562, 7.212891) (129.921875, 14.460938) (129.992188, 21.744141) (130.0625, 29.0625) (129.844592, 32.059167) (129.061318, 34.943376) (127.745482, 37.606991) (125.950352, 39.950352) (123.747616, 41.886107) (121.224626, 43.342568) (118.481042, 44.266467) (115.625, 44.625) (108.271484, 44.695312) (100.882812, 44.765625) (93.458984, 44.835938) (86, 44.90625) (78.505859, 44.976562) (70.976562, 45.046875) (63.412109, 45.117188) (55.8125, 45.1875) (52.815833, 44.969592) (49.931624, 44.186318) (47.268009, 42.870482) (44.924648, 41.075352) (42.988893, 38.872616) (41.532432, 36.349626) (40.608533, 33.606042) (40.25, 30.75) (40.179688, 23.115234) (40.109375, 15.445312) (40.039062, 7.740234) (39.96875, 0) (39.898438, -7.775391) (39.828125, -15.585938) (39.757812, -23.431641) (39.6875, -31.3125) (39.905408, -34.309167) (40.688682, -37.193376) (42.004518, -39.856991) (43.799648, -42.200352) (46.002384, -44.136107) (48.525374, -45.592568) (51.268958, -46.516467) (54.125, -46.875) (62.041016, -46.945312) (69.992188, -47.015625) (77.978516, -47.085938) (86, -47.15625) (94.056641, -47.226562) (102.148438, -47.296875) (110.275391, -47.367188) (118.4375, -47.4375) (121.434167, -47.219592) (124.318376, -46.436318) (126.981991, -45.120482) (129.325352, -43.325352) (131.261107, -41.122616) (132.717568, -38.599626) (133.641467, -35.856042) (134, -33) (134.070312, -24.802734) (134.140625, -16.570312) (134.210938, -8.302734) (134.28125, 0) (134.351562, 8.337891) (134.421875, 16.710938) (134.492188, 25.119141) (134.5625, 33.5625) (134.344592, 36.559167) (133.561318, 39.443376) (132.245482, 42.106991) (130.450352, 44.450352) (128.247616, 46.386107) (125.724626, 47.842568) (122.981042, 48.766467) (120.125, 49.125) (111.646484, 49.195312) (103.132812, 49.265625) (94.583984, 49.335938) (86, 49.40625) (77.380859, 49.476562) (68.726562, 49.546875) (60.037109, 49.617188) (51.3125, 49.6875) (48.315833, 49.469592) (45.431624, 48.686318) (42.768009, 47.370482) (40.424648, 45.575352) (38.488893, 43.372616) (37.032432, 40.849626) (36.108533, 38.106042) (35.75, 35.25) (35.679688, 26.490234) (35.609375, 17.695312) (35.539062, 8.865234) (35.46875, 0) (35.398438, -8.900391) (35.328125, -17.835938) (35.257812, -26.806641) (35.1875, -35.8125) (35.405408, -38.809167) (36.188682, -41.693376) (37.504518, -44.356991)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, section rectangle width=3mm height=0.5mm)
  Rx [copper] = polyline(z=30mm, xy in mm: (30, -15) (30.070312, -11.302734) (30.140625, -7.570312) (30.210938, -3.802734) (30.28125, 0) (30.351562, 3.837891) (30.421875, 7.710938) (30.492188, 11.619141) (30.5625, 15.5625) (30.344592, 18.559167) (29.561318, 21.443376) (28.245482, 24.106991) (26.450352, 26.450352) (24.247616, 28.386107) (21.724626, 29.842568) (18.981042, 30.766467) (16.125, 31.125) (12.146484, 31.195312) (8.132812, 31.265625) (4.083984, 31.335938) (0, 31.40625) (-4.119141, 31.476562) (-8.273438, 31.546875) (-12.462891, 31.617188) (-16.6875, 31.6875) (-19.684167, 31.469592) (-22.568376, 30.686318) (-25.231991, 29.370482) (-27.575352, 27.575352) (-29.511107, 25.372616) (-30.967568, 22.849626) (-31.891467, 20.106042) (-32.25, 17.25) (-32.320312, 12.990234) (-32.390625, 8.695312) (-32.460938, 4.365234) (-32.53125, 0) (-32.601562, -4.400391) (-32.671875, -8.835938) (-32.742188, -13.306641) (-32.8125, -17.8125) (-32.594592, -20.809167) (-31.811318, -23.693376) (-30.495482, -26.356991) (-28.700352, -28.700352) (-26.497616, -30.636107) (-23.974626, -32.092568) (-21.231042, -33.016467) (-18.375, -33.375) (-13.833984, -33.445312) (-9.257812, -33.515625) (-4.646484, -33.585938) (0, -33.65625) (4.681641, -33.726562) (9.398438, -33.796875) (14.150391, -33.867188) (18.9375, -33.9375) (21.934167, -33.719592) (24.818376, -32.936318) (27.481991, -31.620482) (29.825352, -29.825352) (31.761107, -27.622616) (33.217568, -25.099626) (34.141467, -22.356042) (34.5, -19.5) (34.570312, -14.677734) (34.640625, -9.820312) (34.710938, -4.927734) (34.78125, 0) (34.851562, 4.962891) (34.921875, 9.960938) (34.992188, 14.994141) (35.0625, 20.0625) (34.844592, 23.059167) (34.061318, 25.943376) (32.745482, 28.606991) (30.950352, 30.950352) (28.747616, 32.886107) (26.224626, 34.342568) (23.481042, 35.266467) (20.625, 35.625) (15.521484, 35.695312) (10.382812, 35.765625) (5.208984, 35.835938) (0, 35.90625) (-5.244141, 35.976562) (-10.523438, 36.046875) (-15.837891, 36.117188) (-21.1875, 36.1875) (-24.184167, 35.969592) (-27.068376, 35.186318) (-29.731991, 33.870482) (-32.075352, 32.075352) (-34.011107, 29.872616) (-35.467568, 27.349626) (-36.391467, 24.606042) (-36.75, 21.75) (-36.820312, 16.365234) (-36.890625, 10.945312) (-36.960938, 5.490234) (-37.03125, 0) (-37.101562, -5.525391) (-37.171875, -11.085938) (-37.242188, -16.681641) (-37.3125, -22.3125) (-37.094592, -25.309167) (-36.311318, -28.193376) (-34.995482, -30.856991) (-33.200352, -33.200352) (-30.997616, -35.136107) (-28.474626, -36.592568) (-25.731042, -37.516467) (-22.875, -37.875) (-17.208984, -37.945312) (-11.507812, -38.015625) (-5.771484, -38.085938) (0, -38.15625) (5.806641, -38.226562) (11.648438, -38.296875) (17.525391, -38.367188) (23.4375, -38.4375) (26.434167, -38.219592) (29.318376, -37.436318) (31.981991, -36.120482) (34.325352, -34.325352) (36.261107, -32.122616) (37.717568, -29.599626) (38.641467, -26.856042) (39, -24) (39.070312, -18.052734) (39.140625, -12.070312) (39.210938, -6.052734) (39.28125, 0) (39.351562, 6.087891) (39.421875, 12.210938) (39.492188, 18.369141) (39.5625, 24.5625) (39.344592, 27.559167) (38.561318, 30.443376) (37.245482, 33.106991) (35.450352, 35.450352) (33.247616, 37.386107) (30.724626, 38.842568) (27.981042, 39.766467) (25.125, 40.125) (18.896484, 40.195312) (12.632812, 40.265625) (6.333984, 40.335938) (0, 40.40625) (-6.369141, 40.476562) (-12.773438, 40.546875) (-19.212891, 40.617188) (-25.6875, 40.6875) (-28.684167, 40.469592) (-31.568376, 39.686318) (-34.231991, 38.370482) (-36.575352, 36.575352) (-38.511107, 34.372616) (-39.967568, 31.849626) (-40.891467, 29.106042) (-41.25, 26.25) (-41.320312, 19.740234) (-41.390625, 13.195312) (-41.460938, 6.615234) (-41.53125, 0) (-41.601562, -6.650391) (-41.671875, -13.335938) (-41.742188, -20.056641) (-41.8125, -26.8125) (-41.594592, -29.809167) (-40.811318, -32.693376) (-39.495482, -35.356991) (-37.700352, -37.700352) (-35.497616, -39.636107) (-32.974626, -41.092568) (-30.231042, -42.016467) (-27.375, -42.375) (-20.583984, -42.445312) (-13.757812, -42.515625) (-6.896484, -42.585938) (0, -42.65625) (6.931641, -42.726562) (13.898438, -42.796875) (20.900391, -42.867188) (27.9375, -42.9375) (30.934167, -42.719592) (33.818376, -41.936318) (36.481991, -40.620482) (38.825352, -38.825352) (40.761107, -36.622616) (42.217568, -34.099626) (43.141467, -31.356042) (43.5, -28.5) (43.570312, -21.427734) (43.640625, -14.320312) (43.710938, -7.177734) (43.78125, 0) (43.851562, 7.212891) (43.921875, 14.460938) (43.992188, 21.744141) (44.0625, 29.0625) (43.844592, 32.059167) (43.061318, 34.943376) (41.745482, 37.606991) (39.950352, 39.950352) (37.747616, 41.886107) (35.224626, 43.342568) (32.481042, 44.266467) (29.625, 44.625) (22.271484, 44.695312) (14.882812, 44.765625) (7.458984, 44.835938) (0, 44.90625) (-7.494141, 44.976562) (-15.023438, 45.046875) (-22.587891, 45.117188) (-30.1875, 45.1875) (-33.184167, 44.969592) (-36.068376, 44.186318) (-38.731991, 42.870482) (-41.075352, 41.075352) (-43.011107, 38.872616) (-44.467568, 36.349626) (-45.391467, 33.606042) (-45.75, 30.75) (-45.820312, 23.115234) (-45.890625, 15.445312) (-45.960938, 7.740234) (-46.03125, 0) (-46.101562, -7.775391) (-46.171875, -15.585938) (-46.242188, -23.431641) (-46.3125, -31.3125) (-46.094592, -34.309167) (-45.311318, -37.193376) (-43.995482, -39.856991) (-42.200352, -42.200352) (-39.997616, -44.136107) (-37.474626, -45.592568) (-34.731042, -46.516467) (-31.875, -46.875) (-23.958984, -46.945312) (-16.007812, -47.015625) (-8.021484, -47.085938) (0, -47.15625) (8.056641, -47.226562) (16.148438, -47.296875) (24.275391, -47.367188) (32.4375, -47.4375) (35.434167, -47.219592) (38.318376, -46.436318) (40.981991, -45.120482) (43.325352, -43.325352) (45.261107, -41.122616) (46.717568, -38.599626) (47.641467, -35.856042) (48, -33) (48.070312, -24.802734) (48.140625, -16.570312) (48.210938, -8.302734) (48.28125, 0) (48.351562, 8.337891) (48.421875, 16.710938) (48.492188, 25.119141) (48.5625, 33.5625) (48.344592, 36.559167) (47.561318, 39.443376) (46.245482, 42.106991) (44.450352, 44.450352) (42.247616, 46.386107) (39.724626, 47.842568) (36.981042, 48.766467) (34.125, 49.125) (25.646484, 49.195312) (17.132812, 49.265625) (8.583984, 49.335938) (0, 49.40625) (-8.619141, 49.476562) (-17.273438, 49.546875) (-25.962891, 49.617188) (-34.6875, 49.6875) (-37.684167, 49.469592) (-40.568376, 48.686318) (-43.231991, 47.370482) (-45.575352, 45.575352) (-47.511107, 43.372616) (-48.967568, 40.849626) (-49.891467, 38.106042) (-50.25, 35.25) (-50.320312, 26.490234) (-50.390625, 17.695312) (-50.460938, 8.865234) (-50.53125, 0) (-50.601562, -8.900391) (-50.671875, -17.835938) (-50.742188, -26.806641) (-50.8125, -35.8125) (-50.594592, -38.809167) (-49.811318, -41.693376) (-48.495482, -44.356991)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, section rectangle width=3mm height=0.5mm)
  lead_Tx1_a = cylinder(axis=Z, base_centre=(-56mm, -15mm, -45mm), radius=0.3mm, height=45mm)
  lead_Tx1_b = cylinder(axis=Z, base_centre=(-2.36mm, -71.87mm, -45mm), radius=0.3mm, height=45mm)
  lead_Tx2_a = cylinder(axis=Z, base_centre=(116mm, -15mm, -45mm), radius=0.3mm, height=45mm)
  lead_Tx2_b = cylinder(axis=Z, base_centre=(169.64mm, -71.87mm, -45mm), radius=0.3mm, height=45mm)
  lead_Rx_a = cylinder(axis=Z, base_centre=(30mm, -15mm, 30mm), radius=0.3mm, height=45mm)
  lead_Rx_b = cylinder(axis=Z, base_centre=(83.64mm, -71.87mm, 30mm), radius=0.3mm, height=45mm)
  Tx1.unite(lead_Tx1_a, lead_Tx1_b)
  Tx2.unite(lead_Tx2_a, lead_Tx2_b)
  Rx.unite(lead_Rx_a, lead_Rx_b)
  Region [air] = region(absolute_offset: +X=50mm, -X=50mm, +Y=50mm, -Y=50mm, +Z=0mm, -Z=0mm)
boundaries and excitations:
  CT_Tx1_P: Coil Terminal Faces=Tx1.face(at (-2.36, -71.87, -45)) Conductor_number=12 Winding=Winding_Tx1 Point_out_of_terminal=false
  CT_Tx1_N: Coil Terminal Faces=Tx1.face(at (-56, -15, -45)) Conductor_number=12 Winding=Winding_Tx1 Point_out_of_terminal=true
  CT_Tx2_P: Coil Terminal Faces=Tx2.face(at (169.64, -71.87, -45)) Conductor_number=12 Winding=Winding_Tx2 Point_out_of_terminal=false
  CT_Tx2_N: Coil Terminal Faces=Tx2.face(at (116, -15, -45)) Conductor_number=12 Winding=Winding_Tx2 Point_out_of_terminal=true
  CT_Rx_P: Coil Terminal Faces=Rx.face(at (83.64, -71.87, 75)) Conductor_number=12 Winding=Winding_Rx Point_out_of_terminal=false
  CT_Rx_N: Coil Terminal Faces=Rx.face(at (30, -15, 75)) Conductor_number=12 Winding=Winding_Rx Point_out_of_terminal=true
  Winding_Tx1: Winding Group Type=Current IsSolid=false Current=10A ParallelBranchesNum=1 Phase=0deg
  Winding_Tx2: Winding Group Type=Current IsSolid=false Current=10A ParallelBranchesNum=1 Phase=0deg
  Winding_Rx: Winding Group Type=Current IsSolid=false Current=10A ParallelBranchesNum=1 Phase=0deg
parameters:
  Lmatrix: Matrix Winding_Tx1, Winding_Tx2, Winding_Rx:
mesh:
  initial mesh: GlobalCurvilinear{Apply}
setups:
  Setup1: EddyCurrent MaximumPasses=10 MinimumPasses=1 MinimumConvergedPasses=1 PercentRefinement=30 PercentError=1 NonLinearResidual=0.0001 Frequency=85kHz LossAdaptiveCtrl=0.5

design WPT_G (Maxwell 3D, Magnetostatic, model units mm)
geometry:
  Tx1 [copper] = polyline(z=0mm, xy in mm: (-56, -15) (-55.929688, -11.302734) (-55.859375, -7.570312) (-55.789062, -3.802734) (-55.71875, 0) (-55.648438, 3.837891) (-55.578125, 7.710938) (-55.507812, 11.619141) (-55.4375, 15.5625) (-55.655408, 18.559167) (-56.438682, 21.443376) (-57.754518, 24.106991) (-59.549648, 26.450352) (-61.752384, 28.386107) (-64.275374, 29.842568) (-67.018958, 30.766467) (-69.875, 31.125) (-73.853516, 31.195312) (-77.867188, 31.265625) (-81.916016, 31.335938) (-86, 31.40625) (-90.119141, 31.476562) (-94.273438, 31.546875) (-98.462891, 31.617188) (-102.6875, 31.6875) (-105.684167, 31.469592) (-108.568376, 30.686318) (-111.231991, 29.370482) (-113.575352, 27.575352) (-115.511107, 25.372616) (-116.967568, 22.849626) (-117.891467, 20.106042) (-118.25, 17.25) (-118.320312, 12.990234) (-118.390625, 8.695312) (-118.460938, 4.365234) (-118.53125, 0) (-118.601562, -4.400391) (-118.671875, -8.835938) (-118.742188, -13.306641) (-118.8125, -17.8125) (-118.594592, -20.809167) (-117.811318, -23.693376) (-116.495482, -26.356991) (-114.700352, -28.700352) (-112.497616, -30.636107) (-109.974626, -32.092568) (-107.231042, -33.016467) (-104.375, -33.375) (-99.833984, -33.445312) (-95.257812, -33.515625) (-90.646484, -33.585938) (-86, -33.65625) (-81.318359, -33.726562) (-76.601562, -33.796875) (-71.849609, -33.867188) (-67.0625, -33.9375) (-64.065833, -33.719592) (-61.181624, -32.936318) (-58.518009, -31.620482) (-56.174648, -29.825352) (-54.238893, -27.622616) (-52.782432, -25.099626) (-51.858533, -22.356042) (-51.5, -19.5) (-51.429688, -14.677734) (-51.359375, -9.820312) (-51.289062, -4.927734) (-51.21875, 0) (-51.148438, 4.962891) (-51.078125, 9.960938) (-51.007812, 14.994141) (-50.9375, 20.0625) (-51.155408, 23.059167) (-51.938682, 25.943376) (-53.254518, 28.606991) (-55.049648, 30.950352) (-57.252384, 32.886107) (-59.775374, 34.342568) (-62.518958, 35.266467) (-65.375, 35.625) (-70.478516, 35.695312) (-75.617188, 35.765625) (-80.791016, 35.835938) (-86, 35.90625) (-91.244141, 35.976562) (-96.523438, 36.046875) (-101.837891, 36.117188) (-107.1875, 36.1875) (-110.184167, 35.969592) (-113.068376, 35.186318) (-115.731991, 33.870482) (-118.075352, 32.075352) (-120.011107, 29.872616) (-121.467568, 27.349626) (-122.391467, 24.606042) (-122.75, 21.75) (-122.820312, 16.365234) (-122.890625, 10.945312) (-122.960938, 5.490234) (-123.03125, 0) (-123.101562, -5.525391) (-123.171875, -11.085938) (-123.242188, -16.681641) (-123.3125, -22.3125) (-123.094592, -25.309167) (-122.311318, -28.193376) (-120.995482, -30.856991) (-119.200352, -33.200352) (-116.997616, -35.136107) (-114.474626, -36.592568) (-111.731042, -37.516467) (-108.875, -37.875) (-103.208984, -37.945312) (-97.507812, -38.015625) (-91.771484, -38.085938) (-86, -38.15625) (-80.193359, -38.226562) (-74.351562, -38.296875) (-68.474609, -38.367188) (-62.5625, -38.4375) (-59.565833, -38.219592) (-56.681624, -37.436318) (-54.018009, -36.120482) (-51.674648, -34.325352) (-49.738893, -32.122616) (-48.282432, -29.599626) (-47.358533, -26.856042) (-47, -24) (-46.929688, -18.052734) (-46.859375, -12.070312) (-46.789062, -6.052734) (-46.71875, 0) (-46.648438, 6.087891) (-46.578125, 12.210938) (-46.507812, 18.369141) (-46.4375, 24.5625) (-46.655408, 27.559167) (-47.438682, 30.443376) (-48.754518, 33.106991) (-50.549648, 35.450352) (-52.752384, 37.386107) (-55.275374, 38.842568) (-58.018958, 39.766467) (-60.875, 40.125) (-67.103516, 40.195312) (-73.367188, 40.265625) (-79.666016, 40.335938) (-86, 40.40625) (-92.369141, 40.476562) (-98.773438, 40.546875) (-105.212891, 40.617188) (-111.6875, 40.6875) (-114.684167, 40.469592) (-117.568376, 39.686318) (-120.231991, 38.370482) (-122.575352, 36.575352) (-124.511107, 34.372616) (-125.967568, 31.849626) (-126.891467, 29.106042) (-127.25, 26.25) (-127.320312, 19.740234) (-127.390625, 13.195312) (-127.460938, 6.615234) (-127.53125, 0) (-127.601562, -6.650391) (-127.671875, -13.335938) (-127.742188, -20.056641) (-127.8125, -26.8125) (-127.594592, -29.809167) (-126.811318, -32.693376) (-125.495482, -35.356991) (-123.700352, -37.700352) (-121.497616, -39.636107) (-118.974626, -41.092568) (-116.231042, -42.016467) (-113.375, -42.375) (-106.583984, -42.445312) (-99.757812, -42.515625) (-92.896484, -42.585938) (-86, -42.65625) (-79.068359, -42.726562) (-72.101562, -42.796875) (-65.099609, -42.867188) (-58.0625, -42.9375) (-55.065833, -42.719592) (-52.181624, -41.936318) (-49.518009, -40.620482) (-47.174648, -38.825352) (-45.238893, -36.622616) (-43.782432, -34.099626) (-42.858533, -31.356042) (-42.5, -28.5) (-42.429688, -21.427734) (-42.359375, -14.320312) (-42.289062, -7.177734) (-42.21875, 0) (-42.148438, 7.212891) (-42.078125, 14.460938) (-42.007812, 21.744141) (-41.9375, 29.0625) (-42.155408, 32.059167) (-42.938682, 34.943376) (-44.254518, 37.606991) (-46.049648, 39.950352) (-48.252384, 41.886107) (-50.775374, 43.342568) (-53.518958, 44.266467) (-56.375, 44.625) (-63.728516, 44.695312) (-71.117188, 44.765625) (-78.541016, 44.835938) (-86, 44.90625) (-93.494141, 44.976562) (-101.023438, 45.046875) (-108.587891, 45.117188) (-116.1875, 45.1875) (-119.184167, 44.969592) (-122.068376, 44.186318) (-124.731991, 42.870482) (-127.075352, 41.075352) (-129.011107, 38.872616) (-130.467568, 36.349626) (-131.391467, 33.606042) (-131.75, 30.75) (-131.820312, 23.115234) (-131.890625, 15.445312) (-131.960938, 7.740234) (-132.03125, 0) (-132.101562, -7.775391) (-132.171875, -15.585938) (-132.242188, -23.431641) (-132.3125, -31.3125) (-132.094592, -34.309167) (-131.311318, -37.193376) (-129.995482, -39.856991) (-128.200352, -42.200352) (-125.997616, -44.136107) (-123.474626, -45.592568) (-120.731042, -46.516467) (-117.875, -46.875) (-109.958984, -46.945312) (-102.007812, -47.015625) (-94.021484, -47.085938) (-86, -47.15625) (-77.943359, -47.226562) (-69.851562, -47.296875) (-61.724609, -47.367188) (-53.5625, -47.4375) (-50.565833, -47.219592) (-47.681624, -46.436318) (-45.018009, -45.120482) (-42.674648, -43.325352) (-40.738893, -41.122616) (-39.282432, -38.599626) (-38.358533, -35.856042) (-38, -33) (-37.929688, -24.802734) (-37.859375, -16.570312) (-37.789062, -8.302734) (-37.71875, 0) (-37.648438, 8.337891) (-37.578125, 16.710938) (-37.507812, 25.119141) (-37.4375, 33.5625) (-37.655408, 36.559167) (-38.438682, 39.443376) (-39.754518, 42.106991) (-41.549648, 44.450352) (-43.752384, 46.386107) (-46.275374, 47.842568) (-49.018958, 48.766467) (-51.875, 49.125) (-60.353516, 49.195312) (-68.867188, 49.265625) (-77.416016, 49.335938) (-86, 49.40625) (-94.619141, 49.476562) (-103.273438, 49.546875) (-111.962891, 49.617188) (-120.6875, 49.6875) (-123.684167, 49.469592) (-126.568376, 48.686318) (-129.231991, 47.370482) (-131.575352, 45.575352) (-133.511107, 43.372616) (-134.967568, 40.849626) (-135.891467, 38.106042) (-136.25, 35.25) (-136.320312, 26.490234) (-136.390625, 17.695312) (-136.460938, 8.865234) (-136.53125, 0) (-136.601562, -8.900391) (-136.671875, -17.835938) (-136.742188, -26.806641) (-136.8125, -35.8125) (-136.594592, -38.809167) (-135.811318, -41.693376) (-134.495482, -44.356991)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, section rectangle width=3mm height=0.5mm)
  Tx2 [copper] = polyline(z=0mm, xy in mm: (116, -15) (116.070312, -11.302734) (116.140625, -7.570312) (116.210938, -3.802734) (116.28125, 0) (116.351562, 3.837891) (116.421875, 7.710938) (116.492188, 11.619141) (116.5625, 15.5625) (116.344592, 18.559167) (115.561318, 21.443376) (114.245482, 24.106991) (112.450352, 26.450352) (110.247616, 28.386107) (107.724626, 29.842568) (104.981042, 30.766467) (102.125, 31.125) (98.146484, 31.195312) (94.132812, 31.265625) (90.083984, 31.335938) (86, 31.40625) (81.880859, 31.476562) (77.726562, 31.546875) (73.537109, 31.617188) (69.3125, 31.6875) (66.315833, 31.469592) (63.431624, 30.686318) (60.768009, 29.370482) (58.424648, 27.575352) (56.488893, 25.372616) (55.032432, 22.849626) (54.108533, 20.106042) (53.75, 17.25) (53.679688, 12.990234) (53.609375, 8.695312) (53.539062, 4.365234) (53.46875, 0) (53.398438, -4.400391) (53.328125, -8.835938) (53.257812, -13.306641) (53.1875, -17.8125) (53.405408, -20.809167) (54.188682, -23.693376) (55.504518, -26.356991) (57.299648, -28.700352) (59.502384, -30.636107) (62.025374, -32.092568) (64.768958, -33.016467) (67.625, -33.375) (72.166016, -33.445312) (76.742188, -33.515625) (81.353516, -33.585938) (86, -33.65625) (90.681641, -33.726562) (95.398438, -33.796875) (100.150391, -33.867188) (104.9375, -33.9375) (107.934167, -33.719592) (110.818376, -32.936318) (113.481991, -31.620482) (115.825352, -29.825352) (117.761107, -27.622616) (119.217568, -25.099626) (120.141467, -22.356042) (120.5, -19.5) (120.570312, -14.677734) (120.640625, -9.820312) (120.710938, -4.927734) (120.78125, 0) (120.851562, 4.962891) (120.921875, 9.960938) (120.992188, 14.994141) (121.0625, 20.0625) (120.844592, 23.059167) (120.061318, 25.943376) (118.745482, 28.606991) (116.950352, 30.950352) (114.747616, 32.886107) (112.224626, 34.342568) (109.481042, 35.266467) (106.625, 35.625) (101.521484, 35.695312) (96.382812, 35.765625) (91.208984, 35.835938) (86, 35.90625) (80.755859, 35.976562) (75.476562, 36.046875) (70.162109, 36.117188) (64.8125, 36.1875) (61.815833, 35.969592) (58.931624, 35.186318) (56.268009, 33.870482) (53.924648, 32.075352) (51.988893, 29.872616) (50.532432, 27.349626) (49.608533, 24.606042) (49.25, 21.75) (49.179688, 16.365234) (49.109375, 10.945312) (49.039062, 5.490234) (48.96875, 0) (48.898438, -5.525391) (48.828125, -11.085938) (48.757812, -16.681641) (48.6875, -22.3125) (48.905408, -25.309167) (49.688682, -28.193376) (51.004518, -30.856991) (52.799648, -33.200352) (55.002384, -35.136107) (57.525374, -36.592568) (60.268958, -37.516467) (63.125, -37.875) (68.791016, -37.945312) (74.492188, -38.015625) (80.228516, -38.085938) (86, -38.15625) (91.806641, -38.226562) (97.648438, -38.296875) (103.525391, -38.367188) (109.4375, -38.4375) (112.434167, -38.219592) (115.318376, -37.436318) (117.981991, -36.120482) (120.325352, -34.325352) (122.261107, -32.122616) (123.717568, -29.599626) (124.641467, -26.856042) (125, -24) (125.070312, -18.052734) (125.140625, -12.070312) (125.210938, -6.052734) (125.28125, 0) (125.351562, 6.087891) (125.421875, 12.210938) (125.492188, 18.369141) (125.5625, 24.5625) (125.344592, 27.559167) (124.561318, 30.443376) (123.245482, 33.106991) (121.450352, 35.450352) (119.247616, 37.386107) (116.724626, 38.842568) (113.981042, 39.766467) (111.125, 40.125) (104.896484, 40.195312) (98.632812, 40.265625) (92.333984, 40.335938) (86, 40.40625) (79.630859, 40.476562) (73.226562, 40.546875) (66.787109, 40.617188) (60.3125, 40.6875) (57.315833, 40.469592) (54.431624, 39.686318) (51.768009, 38.370482) (49.424648, 36.575352) (47.488893, 34.372616) (46.032432, 31.849626) (45.108533, 29.106042) (44.75, 26.25) (44.679688, 19.740234) (44.609375, 13.195312) (44.539062, 6.615234) (44.46875, 0) (44.398438, -6.650391) (44.328125, -13.335938) (44.257812, -20.056641) (44.1875, -26.8125) (44.405408, -29.809167) (45.188682, -32.693376) (46.504518, -35.356991) (48.299648, -37.700352) (50.502384, -39.636107) (53.025374, -41.092568) (55.768958, -42.016467) (58.625, -42.375) (65.416016, -42.445312) (72.242188, -42.515625) (79.103516, -42.585938) (86, -42.65625) (92.931641, -42.726562) (99.898438, -42.796875) (106.900391, -42.867188) (113.9375, -42.9375) (116.934167, -42.719592) (119.818376, -41.936318) (122.481991, -40.620482) (124.825352, -38.825352) (126.761107, -36.622616) (128.217568, -34.099626) (129.141467, -31.356042) (129.5, -28.5) (129.570312, -21.427734) (129.640625, -14.320312) (129.710938, -7.177734) (129.78125, 0) (129.851562, 7.212891) (129.921875, 14.460938) (129.992188, 21.744141) (130.0625, 29.0625) (129.844592, 32.059167) (129.061318, 34.943376) (127.745482, 37.606991) (125.950352, 39.950352) (123.747616, 41.886107) (121.224626, 43.342568) (118.481042, 44.266467) (115.625, 44.625) (108.271484, 44.695312) (100.882812, 44.765625) (93.458984, 44.835938) (86, 44.90625) (78.505859, 44.976562) (70.976562, 45.046875) (63.412109, 45.117188) (55.8125, 45.1875) (52.815833, 44.969592) (49.931624, 44.186318) (47.268009, 42.870482) (44.924648, 41.075352) (42.988893, 38.872616) (41.532432, 36.349626) (40.608533, 33.606042) (40.25, 30.75) (40.179688, 23.115234) (40.109375, 15.445312) (40.039062, 7.740234) (39.96875, 0) (39.898438, -7.775391) (39.828125, -15.585938) (39.757812, -23.431641) (39.6875, -31.3125) (39.905408, -34.309167) (40.688682, -37.193376) (42.004518, -39.856991) (43.799648, -42.200352) (46.002384, -44.136107) (48.525374, -45.592568) (51.268958, -46.516467) (54.125, -46.875) (62.041016, -46.945312) (69.992188, -47.015625) (77.978516, -47.085938) (86, -47.15625) (94.056641, -47.226562) (102.148438, -47.296875) (110.275391, -47.367188) (118.4375, -47.4375) (121.434167, -47.219592) (124.318376, -46.436318) (126.981991, -45.120482) (129.325352, -43.325352) (131.261107, -41.122616) (132.717568, -38.599626) (133.641467, -35.856042) (134, -33) (134.070312, -24.802734) (134.140625, -16.570312) (134.210938, -8.302734) (134.28125, 0) (134.351562, 8.337891) (134.421875, 16.710938) (134.492188, 25.119141) (134.5625, 33.5625) (134.344592, 36.559167) (133.561318, 39.443376) (132.245482, 42.106991) (130.450352, 44.450352) (128.247616, 46.386107) (125.724626, 47.842568) (122.981042, 48.766467) (120.125, 49.125) (111.646484, 49.195312) (103.132812, 49.265625) (94.583984, 49.335938) (86, 49.40625) (77.380859, 49.476562) (68.726562, 49.546875) (60.037109, 49.617188) (51.3125, 49.6875) (48.315833, 49.469592) (45.431624, 48.686318) (42.768009, 47.370482) (40.424648, 45.575352) (38.488893, 43.372616) (37.032432, 40.849626) (36.108533, 38.106042) (35.75, 35.25) (35.679688, 26.490234) (35.609375, 17.695312) (35.539062, 8.865234) (35.46875, 0) (35.398438, -8.900391) (35.328125, -17.835938) (35.257812, -26.806641) (35.1875, -35.8125) (35.405408, -38.809167) (36.188682, -41.693376) (37.504518, -44.356991)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, section rectangle width=3mm height=0.5mm)
  Rx [copper] = polyline(z=30mm, xy in mm: (30, -15) (30.070312, -11.302734) (30.140625, -7.570312) (30.210938, -3.802734) (30.28125, 0) (30.351562, 3.837891) (30.421875, 7.710938) (30.492188, 11.619141) (30.5625, 15.5625) (30.344592, 18.559167) (29.561318, 21.443376) (28.245482, 24.106991) (26.450352, 26.450352) (24.247616, 28.386107) (21.724626, 29.842568) (18.981042, 30.766467) (16.125, 31.125) (12.146484, 31.195312) (8.132812, 31.265625) (4.083984, 31.335938) (0, 31.40625) (-4.119141, 31.476562) (-8.273438, 31.546875) (-12.462891, 31.617188) (-16.6875, 31.6875) (-19.684167, 31.469592) (-22.568376, 30.686318) (-25.231991, 29.370482) (-27.575352, 27.575352) (-29.511107, 25.372616) (-30.967568, 22.849626) (-31.891467, 20.106042) (-32.25, 17.25) (-32.320312, 12.990234) (-32.390625, 8.695312) (-32.460938, 4.365234) (-32.53125, 0) (-32.601562, -4.400391) (-32.671875, -8.835938) (-32.742188, -13.306641) (-32.8125, -17.8125) (-32.594592, -20.809167) (-31.811318, -23.693376) (-30.495482, -26.356991) (-28.700352, -28.700352) (-26.497616, -30.636107) (-23.974626, -32.092568) (-21.231042, -33.016467) (-18.375, -33.375) (-13.833984, -33.445312) (-9.257812, -33.515625) (-4.646484, -33.585938) (0, -33.65625) (4.681641, -33.726562) (9.398438, -33.796875) (14.150391, -33.867188) (18.9375, -33.9375) (21.934167, -33.719592) (24.818376, -32.936318) (27.481991, -31.620482) (29.825352, -29.825352) (31.761107, -27.622616) (33.217568, -25.099626) (34.141467, -22.356042) (34.5, -19.5) (34.570312, -14.677734) (34.640625, -9.820312) (34.710938, -4.927734) (34.78125, 0) (34.851562, 4.962891) (34.921875, 9.960938) (34.992188, 14.994141) (35.0625, 20.0625) (34.844592, 23.059167) (34.061318, 25.943376) (32.745482, 28.606991) (30.950352, 30.950352) (28.747616, 32.886107) (26.224626, 34.342568) (23.481042, 35.266467) (20.625, 35.625) (15.521484, 35.695312) (10.382812, 35.765625) (5.208984, 35.835938) (0, 35.90625) (-5.244141, 35.976562) (-10.523438, 36.046875) (-15.837891, 36.117188) (-21.1875, 36.1875) (-24.184167, 35.969592) (-27.068376, 35.186318) (-29.731991, 33.870482) (-32.075352, 32.075352) (-34.011107, 29.872616) (-35.467568, 27.349626) (-36.391467, 24.606042) (-36.75, 21.75) (-36.820312, 16.365234) (-36.890625, 10.945312) (-36.960938, 5.490234) (-37.03125, 0) (-37.101562, -5.525391) (-37.171875, -11.085938) (-37.242188, -16.681641) (-37.3125, -22.3125) (-37.094592, -25.309167) (-36.311318, -28.193376) (-34.995482, -30.856991) (-33.200352, -33.200352) (-30.997616, -35.136107) (-28.474626, -36.592568) (-25.731042, -37.516467) (-22.875, -37.875) (-17.208984, -37.945312) (-11.507812, -38.015625) (-5.771484, -38.085938) (0, -38.15625) (5.806641, -38.226562) (11.648438, -38.296875) (17.525391, -38.367188) (23.4375, -38.4375) (26.434167, -38.219592) (29.318376, -37.436318) (31.981991, -36.120482) (34.325352, -34.325352) (36.261107, -32.122616) (37.717568, -29.599626) (38.641467, -26.856042) (39, -24) (39.070312, -18.052734) (39.140625, -12.070312) (39.210938, -6.052734) (39.28125, 0) (39.351562, 6.087891) (39.421875, 12.210938) (39.492188, 18.369141) (39.5625, 24.5625) (39.344592, 27.559167) (38.561318, 30.443376) (37.245482, 33.106991) (35.450352, 35.450352) (33.247616, 37.386107) (30.724626, 38.842568) (27.981042, 39.766467) (25.125, 40.125) (18.896484, 40.195312) (12.632812, 40.265625) (6.333984, 40.335938) (0, 40.40625) (-6.369141, 40.476562) (-12.773438, 40.546875) (-19.212891, 40.617188) (-25.6875, 40.6875) (-28.684167, 40.469592) (-31.568376, 39.686318) (-34.231991, 38.370482) (-36.575352, 36.575352) (-38.511107, 34.372616) (-39.967568, 31.849626) (-40.891467, 29.106042) (-41.25, 26.25) (-41.320312, 19.740234) (-41.390625, 13.195312) (-41.460938, 6.615234) (-41.53125, 0) (-41.601562, -6.650391) (-41.671875, -13.335938) (-41.742188, -20.056641) (-41.8125, -26.8125) (-41.594592, -29.809167) (-40.811318, -32.693376) (-39.495482, -35.356991) (-37.700352, -37.700352) (-35.497616, -39.636107) (-32.974626, -41.092568) (-30.231042, -42.016467) (-27.375, -42.375) (-20.583984, -42.445312) (-13.757812, -42.515625) (-6.896484, -42.585938) (0, -42.65625) (6.931641, -42.726562) (13.898438, -42.796875) (20.900391, -42.867188) (27.9375, -42.9375) (30.934167, -42.719592) (33.818376, -41.936318) (36.481991, -40.620482) (38.825352, -38.825352) (40.761107, -36.622616) (42.217568, -34.099626) (43.141467, -31.356042) (43.5, -28.5) (43.570312, -21.427734) (43.640625, -14.320312) (43.710938, -7.177734) (43.78125, 0) (43.851562, 7.212891) (43.921875, 14.460938) (43.992188, 21.744141) (44.0625, 29.0625) (43.844592, 32.059167) (43.061318, 34.943376) (41.745482, 37.606991) (39.950352, 39.950352) (37.747616, 41.886107) (35.224626, 43.342568) (32.481042, 44.266467) (29.625, 44.625) (22.271484, 44.695312) (14.882812, 44.765625) (7.458984, 44.835938) (0, 44.90625) (-7.494141, 44.976562) (-15.023438, 45.046875) (-22.587891, 45.117188) (-30.1875, 45.1875) (-33.184167, 44.969592) (-36.068376, 44.186318) (-38.731991, 42.870482) (-41.075352, 41.075352) (-43.011107, 38.872616) (-44.467568, 36.349626) (-45.391467, 33.606042) (-45.75, 30.75) (-45.820312, 23.115234) (-45.890625, 15.445312) (-45.960938, 7.740234) (-46.03125, 0) (-46.101562, -7.775391) (-46.171875, -15.585938) (-46.242188, -23.431641) (-46.3125, -31.3125) (-46.094592, -34.309167) (-45.311318, -37.193376) (-43.995482, -39.856991) (-42.200352, -42.200352) (-39.997616, -44.136107) (-37.474626, -45.592568) (-34.731042, -46.516467) (-31.875, -46.875) (-23.958984, -46.945312) (-16.007812, -47.015625) (-8.021484, -47.085938) (0, -47.15625) (8.056641, -47.226562) (16.148438, -47.296875) (24.275391, -47.367188) (32.4375, -47.4375) (35.434167, -47.219592) (38.318376, -46.436318) (40.981991, -45.120482) (43.325352, -43.325352) (45.261107, -41.122616) (46.717568, -38.599626) (47.641467, -35.856042) (48, -33) (48.070312, -24.802734) (48.140625, -16.570312) (48.210938, -8.302734) (48.28125, 0) (48.351562, 8.337891) (48.421875, 16.710938) (48.492188, 25.119141) (48.5625, 33.5625) (48.344592, 36.559167) (47.561318, 39.443376) (46.245482, 42.106991) (44.450352, 44.450352) (42.247616, 46.386107) (39.724626, 47.842568) (36.981042, 48.766467) (34.125, 49.125) (25.646484, 49.195312) (17.132812, 49.265625) (8.583984, 49.335938) (0, 49.40625) (-8.619141, 49.476562) (-17.273438, 49.546875) (-25.962891, 49.617188) (-34.6875, 49.6875) (-37.684167, 49.469592) (-40.568376, 48.686318) (-43.231991, 47.370482) (-45.575352, 45.575352) (-47.511107, 43.372616) (-48.967568, 40.849626) (-49.891467, 38.106042) (-50.25, 35.25) (-50.320312, 26.490234) (-50.390625, 17.695312) (-50.460938, 8.865234) (-50.53125, 0) (-50.601562, -8.900391) (-50.671875, -17.835938) (-50.742188, -26.806641) (-50.8125, -35.8125) (-50.594592, -38.809167) (-49.811318, -41.693376) (-48.495482, -44.356991)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, section rectangle width=3mm height=0.5mm)
  lead_Tx1_a = cylinder(axis=Z, base_centre=(-56mm, -15mm, -45mm), radius=0.3mm, height=45mm)
  lead_Tx1_b = cylinder(axis=Z, base_centre=(-2.36mm, -71.87mm, -45mm), radius=0.3mm, height=45mm)
  lead_Tx2_a = cylinder(axis=Z, base_centre=(116mm, -15mm, -45mm), radius=0.3mm, height=45mm)
  lead_Tx2_b = cylinder(axis=Z, base_centre=(169.64mm, -71.87mm, -45mm), radius=0.3mm, height=45mm)
  lead_Rx_a = cylinder(axis=Z, base_centre=(30mm, -15mm, 30mm), radius=0.3mm, height=45mm)
  lead_Rx_b = cylinder(axis=Z, base_centre=(83.64mm, -71.87mm, 30mm), radius=0.3mm, height=45mm)
  Tx1.unite(lead_Tx1_a, lead_Tx1_b)
  Tx2.unite(lead_Tx2_a, lead_Tx2_b)
  Rx.unite(lead_Rx_a, lead_Rx_b)
  Region [air] = region(absolute_offset: +X=50mm, -X=50mm, +Y=50mm, -Y=50mm, +Z=0mm, -Z=0mm)
  Rx.move(-50mm, 0mm, 0mm)
  Rx.move(10mm, 0mm, 0mm)
  Rx.move(39.374849mm, 0mm, 0mm)
  Rx.move(-50mm, 0mm, 0mm)
  Rx.move(50mm, 0mm, 0mm)
  Rx.move(-50mm, 0mm, 0mm)
  Rx.move(50mm, 0mm, 0mm)
  Rx.move(-50mm, 0mm, 0mm)
  Rx.move(10mm, 0mm, 0mm)
  Rx.move(-10mm, 0mm, 0mm)
  Rx.move(50mm, 0mm, 0mm)
  Rx.move(-50mm, 0mm, 0mm)
  Rx.move(10mm, 0mm, 0mm)
  Rx.move(-10mm, 0mm, 0mm)
  Rx.move(50mm, 0mm, 0mm)
  Rx.move(-50mm, 0mm, 0mm)
  Rx.move(10mm, 0mm, 0mm)
  Rx.move(10mm, 0mm, 0mm)
  Rx.move(30mm, 0mm, 0mm)
  Rx.move(-50mm, 0mm, 0mm)
  Rx.move(10mm, 0mm, 0mm)
  Rx.move(40mm, 0mm, 0mm)
  Rx.move(-50mm, 0mm, 0mm)
  Rx.move(10mm, 0mm, 0mm)
  Rx.move(10mm, 0mm, 0mm)
  Rx.move(10mm, 0mm, 0mm)
  Rx.move(10mm, 0mm, 0mm)
  Rx.move(10mm, 0mm, 0mm)
  Rx.move(10mm, 0mm, 0mm)
  Rx.move(10mm, 0mm, 0mm)
  Rx.move(10mm, 0mm, 0mm)
  Rx.move(10mm, 0mm, 0mm)
  Rx.move(10mm, 0mm, 0mm)
  Rx.move(-50mm, 0mm, 0mm)
  Rx.move(-50mm, 0mm, 0mm)
  Rx.move(10mm, 0mm, 0mm)
  Rx.move(10mm, 0mm, 0mm)
  Rx.move(10mm, 0mm, 0mm)
  Rx.move(20mm, 0mm, 0mm)
  Rx.move(10mm, 0mm, 0mm)
  Rx.move(10mm, 0mm, 0mm)
  Rx.move(10mm, 0mm, 0mm)
  Rx.move(10mm, 0mm, 0mm)
  Rx.move(10mm, 0mm, 0mm)
  Rx.move(10mm, 0mm, 0mm)
  Rx.move(10mm, 0mm, 0mm)
  Rx.move(10mm, 0mm, 0mm)
  Rx.move(-80mm, 0mm, 0mm)
  Rx.move(-50mm, 0mm, 0mm)
  Rx.move(10mm, 0mm, 0mm)
  Rx.move(10mm, 0mm, 0mm)
  Rx.move(10mm, 0mm, 0mm)
  Rx.move(10mm, 0mm, 0mm)
  Rx.move(10mm, 0mm, 0mm)
  Rx.move(10mm, 0mm, 0mm)
  Rx.move(10mm, 0mm, 0mm)
  Rx.move(10mm, 0mm, 0mm)
  Rx.move(10mm, 0mm, 0mm)
  Rx.move(10mm, 0mm, 0mm)
  Rx.move(-50mm, 0mm, 0mm)
  Rx.move(-50mm, 0mm, 0mm)
  Rx.move(10mm, 0mm, 0mm)
  Rx.move(10mm, 0mm, 0mm)
  Rx.move(30mm, 0mm, 0mm)
  Rx.move(10mm, 0mm, 0mm)
  Rx.move(10mm, 0mm, 0mm)
  Rx.move(10mm, 0mm, 0mm)
  Rx.move(10mm, 0mm, 0mm)
  Rx.move(10mm, 0mm, 0mm)
  Rx.move(10mm, 0mm, 0mm)
  Rx.move(10mm, 0mm, 0mm)
  Rx.move(10mm, 0mm, 0mm)
  Rx.move(10mm, 0mm, 0mm)
  Rx.move(-90mm, 0mm, 0mm)
  Rx.move(-50mm, 0mm, 0mm)
  Rx.move(10mm, 0mm, 0mm)
  Rx.move(10mm, 0mm, 0mm)
  Rx.move(10mm, 0mm, 0mm)
  Rx.move(10mm, 0mm, 0mm)
  Rx.move(10mm, 0mm, 0mm)
  Rx.move(10mm, 0mm, 0mm)
  Rx.move(10mm, 0mm, 0mm)
  Rx.move(-20mm, 0mm, 0mm)
  Rx.move(-10mm, 0mm, 0mm)
  Rx.move(10mm, 0mm, 0mm)
  Rx.move(-50mm, 0mm, 0mm)
  Rx.move(10mm, 0mm, 0mm)
  Rx.move(10mm, 0mm, 0mm)
  Rx.move(10mm, 0mm, 0mm)
  Rx.move(10mm, 0mm, 0mm)
  Rx.move(10mm, 0mm, 0mm)
  Rx.move(10mm, 0mm, 0mm)
  Rx.move(-10mm, 0mm, 0mm)
  Rx.move(10mm, 0mm, 0mm)
  Rx.move(10mm, 0mm, 0mm)
  Rx.move(10mm, 0mm, 0mm)
  Rx.move(10mm, 0mm, 0mm)
  Rx.move(10mm, 0mm, 0mm)
  Rx.move(-50mm, 0mm, 0mm)
  Tx1.move(0.92484914mm, 0mm, 0mm)
  Tx2.move(-2.1751509mm, 0mm, 0mm)
  Tx1.move(-45mm, 0mm, 0mm)
  Tx2.move(45mm, 0mm, 0mm)
  Rx.move(110mm, 0mm, 0mm)
  Rx.move(-110mm, 0mm, 0mm)
  Tx1.move(45mm, 0mm, 0mm)
  Tx2.move(-45mm, 0mm, 0mm)
  Tx1.move(-60mm, 0mm, 0mm)
  Tx2.move(60mm, 0mm, 0mm)
  Rx.move(-50mm, 0mm, 0mm)
  Rx.move(50mm, 0mm, 0mm)
  Rx.move(-150mm, 0mm, 0mm)
  Rx.move(150mm, 0mm, 0mm)
  Rx.move(-150mm, 0mm, 0mm)
  Rx.move(150mm, 0mm, 0mm)
  Tx1.move(15mm, 0mm, 0mm)
  Tx2.move(-15mm, 0mm, 0mm)
  Rx.move(110mm, 0mm, 0mm)
  Rx.move(-110mm, 0mm, 0mm)
  Tx1.move(45mm, 0mm, 0mm)
  Tx2.move(-45mm, 0mm, 0mm)
  Tx1.move(-15mm, 0mm, 0mm)
  [Tx2, Tx1].move(15mm, 0mm, 0mm)
  Tx2.move(-15mm, 0mm, 0mm)
  Tx1.move(-45mm, 0mm, 0mm)
  Tx2.move(45mm, 0mm, 0mm)
  Rx.move(110mm, 0mm, 0mm)
  Rx.move(10mm, 0mm, 0mm)
  Rx.move(-120mm, 0mm, 0mm)
  Rx.move(120mm, 0mm, 0mm)
  Rx.move(10mm, 0mm, 0mm)
  Rx.move(10mm, 0mm, 0mm)
  Rx.move(10mm, 0mm, 0mm)
  Rx.move(-150mm, 0mm, 0mm)
  Tx1.move(-15mm, 0mm, 0mm)
  Tx2.move(15mm, 0mm, 0mm)
  Rx.move(-150mm, 0mm, 0mm)
  Rx.move(150mm, 0mm, 0mm)
  Rx.move(-140mm, 0mm, 0mm)
  Rx.move(10mm, 0mm, 0mm)
  Rx.move(10mm, 0mm, 0mm)
  Rx.move(10mm, 0mm, 0mm)
  Rx.move(10mm, 0mm, 0mm)
  Rx.move(10mm, 0mm, 0mm)
  Rx.move(10mm, 0mm, 0mm)
  Rx.move(10mm, 0mm, 0mm)
  Rx.move(10mm, 0mm, 0mm)
  Rx.move(10mm, 0mm, 0mm)
  Rx.move(10mm, 0mm, 0mm)
  Rx.move(10mm, 0mm, 0mm)
  Rx.move(10mm, 0mm, 0mm)
  Rx.move(10mm, 0mm, 0mm)
  Rx.move(10mm, 0mm, 0mm)
  Rx.move(10mm, 0mm, 0mm)
  Rx.move(10mm, 0mm, 0mm)
  Rx.move(10mm, 0mm, 0mm)
  Rx.move(10mm, 0mm, 0mm)
  Rx.move(10mm, 0mm, 0mm)
  Rx.move(10mm, 0mm, 0mm)
  Rx.move(10mm, 0mm, 0mm)
  Rx.move(10mm, 0mm, 0mm)
  Rx.move(10mm, 0mm, 0mm)
  Rx.move(10mm, 0mm, 0mm)
  Rx.move(10mm, 0mm, 0mm)
  Rx.move(-110mm, 0mm, 0mm)
  Rx.move(120mm, 0mm, 0mm)
  Rx.move(10mm, 0mm, 0mm)
  Rx.move(10mm, 0mm, 0mm)
  Rx.move(10mm, 0mm, 0mm)
  Rx.move(-150mm, 0mm, 0mm)
  Tx1.move(60mm, 0mm, 0mm)
  Tx2.move(-60mm, 0mm, 0mm)
  Rx.move(-150mm, 0mm, 0mm)
  Rx.move(10mm, 0mm, 0mm)
  Rx.move(10mm, 0mm, 0mm)
  Rx.move(10mm, 0mm, 0mm)
  Rx.move(10mm, 0mm, 0mm)
  Rx.move(10mm, 0mm, 0mm)
  Rx.move(10mm, 0mm, 0mm)
  Rx.move(10mm, 0mm, 0mm)
  Rx.move(10mm, 0mm, 0mm)
  Rx.move(10mm, 0mm, 0mm)
  Rx.move(10mm, 0mm, 0mm)
  Rx.move(10mm, 0mm, 0mm)
  Rx.move(10mm, 0mm, 0mm)
  Rx.move(10mm, 0mm, 0mm)
  Rx.move(10mm, 0mm, 0mm)
  Rx.move(10mm, 0mm, 0mm)
  Rx.move(10mm, 0mm, 0mm)
  Rx.move(10mm, 0mm, 0mm)
  Rx.move(10mm, 0mm, 0mm)
  Rx.move(10mm, 0mm, 0mm)
  Rx.move(10mm, 0mm, 0mm)
  Rx.move(10mm, 0mm, 0mm)
  Rx.move(10mm, 0mm, 0mm)
  Rx.move(10mm, 0mm, 0mm)
  Rx.move(10mm, 0mm, 0mm)
  Rx.move(10mm, 0mm, 0mm)
  Rx.move(-100mm, 0mm, 0mm)
  Rx.move(110mm, 0mm, 0mm)
  Rx.move(10mm, 0mm, 0mm)
  Rx.move(10mm, 0mm, 0mm)
  Rx.move(10mm, 0mm, 0mm)
  Rx.move(10mm, 0mm, 0mm)
  Rx.move(-150mm, 0mm, 0mm)
  Tx1.move(-15mm, 0mm, 0mm)
  Tx2.move(15mm, 0mm, 0mm)
  Rx.move(-150mm, 0mm, 0mm)
  Rx.move(10mm, 0mm, 0mm)
  Rx.move(140mm, 0mm, 0mm)
  Rx.move(-130mm, 0mm, 0mm)
  Rx.move(10mm, 0mm, 0mm)
  Rx.move(10mm, 0mm, 0mm)
  Rx.move(10mm, 0mm, 0mm)
  Rx.move(10mm, 0mm, 0mm)
  Rx.move(10mm, 0mm, 0mm)
  Rx.move(10mm, 0mm, 0mm)
  Rx.move(10mm, 0mm, 0mm)
  Rx.move(10mm, 0mm, 0mm)
  Rx.move(10mm, 0mm, 0mm)
  Rx.move(10mm, 0mm, 0mm)
  Rx.move(10mm, 0mm, 0mm)
  Rx.move(10mm, 0mm, 0mm)
  Rx.move(10mm, 0mm, 0mm)
  Rx.move(10mm, 0mm, 0mm)
  Rx.move(10mm, 0mm, 0mm)
  Rx.move(10mm, 0mm, 0mm)
  Rx.move(10mm, 0mm, 0mm)
  Rx.move(10mm, 0mm, 0mm)
  Rx.move(10mm, 0mm, 0mm)
  Rx.move(10mm, 0mm, 0mm)
  Rx.move(10mm, 0mm, 0mm)
  Rx.move(10mm, 0mm, 0mm)
  Rx.move(10mm, 0mm, 0mm)
  Rx.move(-100mm, 0mm, 0mm)
  Rx.move(110mm, 0mm, 0mm)
  Rx.move(10mm, 0mm, 0mm)
  Rx.move(10mm, 0mm, 0mm)
  Rx.move(10mm, 0mm, 0mm)
  Rx.move(10mm, 0mm, 0mm)
  Rx.move(-150mm, 0mm, 0mm)
  Tx1.move(-15mm, 0mm, 0mm)
  Tx2.move(15mm, 0mm, 0mm)
  Rx.move(-150mm, 0mm, 0mm)
  Rx.move(10mm, 0mm, 0mm)
  Rx.move(10mm, 0mm, 0mm)
  Rx.move(10mm, 0mm, 0mm)
  Rx.move(10mm, 0mm, 0mm)
  Rx.move(10mm, 0mm, 0mm)
  Rx.move(10mm, 0mm, 0mm)
  Rx.move(10mm, 0mm, 0mm)
  Rx.move(10mm, 0mm, 0mm)
  Rx.move(10mm, 0mm, 0mm)
  Rx.move(10mm, 0mm, 0mm)
  Rx.move(10mm, 0mm, 0mm)
  Rx.move(10mm, 0mm, 0mm)
  Rx.move(10mm, 0mm, 0mm)
  Rx.move(10mm, 0mm, 0mm)
  Rx.move(10mm, 0mm, 0mm)
  Rx.move(10mm, 0mm, 0mm)
  Rx.move(10mm, 0mm, 0mm)
  Rx.move(10mm, 0mm, 0mm)
  Rx.move(10mm, 0mm, 0mm)
  Rx.move(10mm, 0mm, 0mm)
  Rx.move(10mm, 0mm, 0mm)
  Rx.move(10mm, 0mm, 0mm)
  Rx.move(10mm, 0mm, 0mm)
  Rx.move(10mm, 0mm, 0mm)
  Rx.move(-90mm, 0mm, 0mm)
  Rx.move(100mm, 0mm, 0mm)
  Rx.move(10mm, 0mm, 0mm)
  Rx.move(10mm, 0mm, 0mm)
  Rx.move(10mm, 0mm, 0mm)
  Rx.move(10mm, 0mm, 0mm)
  Rx.move(10mm, 0mm, 0mm)
  Rx.move(-150mm, 0mm, 0mm)
  Tx1.move(-15mm, 0mm, 0mm)
  Tx2.move(15mm, 0mm, 0mm)
  Rx.move(-150mm, 0mm, 0mm)
  Rx.move(10mm, 0mm, 0mm)
  Rx.move(10mm, 0mm, 0mm)
  Rx.move(10mm, 0mm, 0mm)
  Rx.move(10mm, 0mm, 0mm)
  Rx.move(10mm, 0mm, 0mm)
  Rx.move(10mm, 0mm, 0mm)
  Rx.move(10mm, 0mm, 0mm)
  Rx.move(10mm, 0mm, 0mm)
  Rx.move(10mm, 0mm, 0mm)
  Rx.move(10mm, 0mm, 0mm)
  Rx.move(10mm, 0mm, 0mm)
  Rx.move(10mm, 0mm, 0mm)
  Rx.move(10mm, 0mm, 0mm)
  Rx.move(10mm, 0mm, 0mm)
  Rx.move(10mm, 0mm, 0mm)
  Rx.move(10mm, 0mm, 0mm)
  Rx.move(10mm, 0mm, 0mm)
  Rx.move(10mm, 0mm, 0mm)
  Rx.move(10mm, 0mm, 0mm)
  Rx.move(10mm, 0mm, 0mm)
  Rx.move(10mm, 0mm, 0mm)
  Rx.move(10mm, 0mm, 0mm)
  Rx.move(10mm, 0mm, 0mm)
  Rx.move(-80mm, 0mm, 0mm)
  Rx.move(90mm, 0mm, 0mm)
  Rx.move(10mm, 0mm, 0mm)
  Rx.move(10mm, 0mm, 0mm)
  Rx.move(10mm, 0mm, 0mm)
  Rx.move(10mm, 0mm, 0mm)
  Rx.move(10mm, 0mm, 0mm)
  Rx.move(10mm, 0mm, 0mm)
  Rx.move(-150mm, 0mm, 0mm)
  Tx1.move(-15mm, 0mm, 0mm)
  Tx2.move(15mm, 0mm, 0mm)
  Rx.move(-150mm, 0mm, 0mm)
  Rx.move(10mm, 0mm, 0mm)
  Rx.move(10mm, 0mm, 0mm)
  Rx.move(10mm, 0mm, 0mm)
  Rx.move(10mm, 0mm, 0mm)
  Rx.move(10mm, 0mm, 0mm)
  Rx.move(10mm, 0mm, 0mm)
  Rx.move(10mm, 0mm, 0mm)
  Rx.move(10mm, 0mm, 0mm)
  Rx.move(10mm, 0mm, 0mm)
  Rx.move(10mm, 0mm, 0mm)
  Rx.move(10mm, 0mm, 0mm)
  Rx.move(10mm, 0mm, 0mm)
  Rx.move(10mm, 0mm, 0mm)
  Rx.move(10mm, 0mm, 0mm)
  Rx.move(10mm, 0mm, 0mm)
  Rx.move(10mm, 0mm, 0mm)
  Rx.move(10mm, 0mm, 0mm)
  Rx.move(10mm, 0mm, 0mm)
  Rx.move(10mm, 0mm, 0mm)
  Rx.move(10mm, 0mm, 0mm)
  Rx.move(10mm, 0mm, 0mm)
  Rx.move(10mm, 0mm, 0mm)
  Rx.move(-70mm, 0mm, 0mm)
  Rx.move(80mm, 0mm, 0mm)
  Rx.move(10mm, 0mm, 0mm)
  Rx.move(10mm, 0mm, 0mm)
  Rx.move(10mm, 0mm, 0mm)
  Rx.move(10mm, 0mm, 0mm)
  Rx.move(10mm, 0mm, 0mm)
  Rx.move(10mm, 0mm, 0mm)
  Rx.move(10mm, 0mm, 0mm)
  Rx.move(-150mm, 0mm, 0mm)
  Rx.move(-150mm, 0mm, 0mm)
  Rx.move(150mm, 0mm, 0mm)
  Tx1.move(45mm, 0mm, 0mm)
  Tx2.move(-45mm, 0mm, 0mm)
  ferrite_Tx_0 [ferrite] = box(corner=(-205mm, -84mm, -40mm), size=(20mm, 168mm, 10mm))
  ferrite_Tx_1 [ferrite] = box(corner=(-175mm, -84mm, -40mm), size=(20mm, 168mm, 10mm))
  ferrite_Tx_2 [ferrite] = box(corner=(-145mm, -84mm, -40mm), size=(20mm, 168mm, 10mm))
  ferrite_Tx_3 [ferrite] = box(corner=(-115mm, -84mm, -40mm), size=(20mm, 168mm, 10mm))
  ferrite_Tx_4 [ferrite] = box(corner=(-85mm, -84mm, -40mm), size=(20mm, 168mm, 10mm))
  ferrite_Tx_5 [ferrite] = box(corner=(-55mm, -84mm, -40mm), size=(20mm, 168mm, 10mm))
  ferrite_Tx_6 [ferrite] = box(corner=(-25mm, -84mm, -40mm), size=(20mm, 168mm, 10mm))
  ferrite_Tx_7 [ferrite] = box(corner=(5mm, -84mm, -40mm), size=(20mm, 168mm, 10mm))
  ferrite_Tx_8 [ferrite] = box(corner=(35mm, -84mm, -40mm), size=(20mm, 168mm, 10mm))
  ferrite_Tx_9 [ferrite] = box(corner=(65mm, -84mm, -40mm), size=(20mm, 168mm, 10mm))
  ferrite_Tx_10 [ferrite] = box(corner=(95mm, -84mm, -40mm), size=(20mm, 168mm, 10mm))
  ferrite_Tx_11 [ferrite] = box(corner=(125mm, -84mm, -40mm), size=(20mm, 168mm, 10mm))
  ferrite_Tx_12 [ferrite] = box(corner=(155mm, -84mm, -40mm), size=(20mm, 168mm, 10mm))
  ferrite_Tx_13 [ferrite] = box(corner=(185mm, -84mm, -40mm), size=(20mm, 168mm, 10mm))
  ferrite_Rx_0 [ferrite] = box(corner=(-100mm, -84mm, 60mm), size=(20mm, 168mm, 10mm))
  ferrite_Rx_1 [ferrite] = box(corner=(-70mm, -84mm, 60mm), size=(20mm, 168mm, 10mm))
  ferrite_Rx_2 [ferrite] = box(corner=(-40mm, -84mm, 60mm), size=(20mm, 168mm, 10mm))
  ferrite_Rx_3 [ferrite] = box(corner=(-10mm, -84mm, 60mm), size=(20mm, 168mm, 10mm))
  ferrite_Rx_4 [ferrite] = box(corner=(20mm, -84mm, 60mm), size=(20mm, 168mm, 10mm))
  ferrite_Rx_5 [ferrite] = box(corner=(50mm, -84mm, 60mm), size=(20mm, 168mm, 10mm))
  ferrite_Rx_6 [ferrite] = box(corner=(80mm, -84mm, 60mm), size=(20mm, 168mm, 10mm))
  aux_hole = cylinder(axis=Z, base_centre=(-70.05mm, -15mm, -45mm), radius=1mm, height=45mm)
  ferrite_Tx_4.subtract(aux_hole)
  aux_hole_1 = cylinder(axis=Z, base_centre=(-16.45mm, -71.87mm, -45mm), radius=1mm, height=45mm)
  ferrite_Tx_6.subtract(aux_hole_1)
  aux_hole_2 = cylinder(axis=Z, base_centre=(128.85mm, -15mm, -45mm), radius=1mm, height=45mm)
  ferrite_Tx_11.subtract(aux_hole_2)
  aux_hole_3 = cylinder(axis=Z, base_centre=(30mm, -15mm, 30mm), radius=1mm, height=45mm)
  ferrite_Rx_4.subtract(aux_hole_3)
  aux_hole_4 = cylinder(axis=Z, base_centre=(83.64mm, -71.87mm, 30mm), radius=1mm, height=45mm)
  ferrite_Rx_6.subtract(aux_hole_4)
  [Rx, ferrite_Rx_0..ferrite_Rx_6].move(-140mm, 0mm, 0mm)
boundaries and excitations:
  CT_Tx1_P: Coil Terminal Faces=Tx1.face(at (-16.4352, -71.87, -45)) Conductor_number=12 Winding=Winding_Tx1 Point_out_of_terminal=false
  CT_Tx1_N: Coil Terminal Faces=Tx1.face(at (-70.0752, -15, -45)) Conductor_number=12 Winding=Winding_Tx1 Point_out_of_terminal=true
  CT_Tx2_P: Coil Terminal Faces=Tx2.face(at (182.465, -71.87, -45)) Conductor_number=12 Winding=Winding_Tx2 Point_out_of_terminal=false
  CT_Tx2_N: Coil Terminal Faces=Tx2.face(at (128.825, -15, -45)) Conductor_number=12 Winding=Winding_Tx2 Point_out_of_terminal=true
  CT_Rx_P: Coil Terminal Faces=Rx.face(at (-56.9852, -71.87, 75)) Conductor_number=12 Winding=Winding_Rx Point_out_of_terminal=false
  CT_Rx_N: Coil Terminal Faces=Rx.face(at (-110.625, -15, 75)) Conductor_number=12 Winding=Winding_Rx Point_out_of_terminal=true
  Winding_Tx1: Winding Group Type=Current IsSolid=false Current=10A ParallelBranchesNum=1
  Winding_Tx2: Winding Group Type=Current IsSolid=false Current=10A ParallelBranchesNum=1
  Winding_Rx: Winding Group Type=Current IsSolid=false Current=0A ParallelBranchesNum=1
parameters:
  Lmatrix: Matrix Winding_Tx1, Winding_Tx2, Winding_Rx: NumberOfTurns=1
mesh:
  initial mesh: GlobalCurvilinear{Apply}
setups:
  Setup1: Magnetostatic MaximumPasses=8 MinimumPasses=2 MinimumConvergedPasses=1 PercentRefinement=5 PercentError=5 RelativeResidual=1e-06 NonLinearResidual=0.001
